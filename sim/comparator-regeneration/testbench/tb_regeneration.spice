* tb_regeneration -- decision time versus input overdrive, the regeneration
* time constant tau extracted from it, and the switching energy per decision.
*
* Netlist FRAGMENT. The harness supplies the models, the corner .lib
* section, .temp, the DUT netlist, the .control block and .end
* (sim/harness/README.md). Parameters from the harness: vdd_val, vdd_nom,
* temp_c, dut_ib, dut_vcm.
*
* METHODOLOGY PORTED FROM gf180-comparator/sim/comparator-regeneration/
* (itself ported from gf180-sar-adc) -- see this experiment's README.md for
* the full transfer/non-transfer list.
*
* WHAT THIS ANSWERS
*
* 1. Is the decision complete inside the budget at the WORST PVT corner,
*    rather than at a typical-corner estimate? README.md's decision-time row
*    is stated at 50 mV overdrive, so 50 mV is the primary rung of the
*    ladder below.
*
* 2. The regeneration time constant tau, EXTRACTED rather than assumed. A
*    regenerative latch resolves in t = t0 + tau*ln(V_logic/(A_v*V_in)), so
*    the delay difference between two KNOWN overdrives gives tau directly:
*        tau = (t(V_small) - t(V_large)) / ln(V_large/V_small)
*    Everything downstream -- the metastability window -- is computed from
*    tau, so tau is the quantity that must be measured, not the delay at one
*    overdrive. Metastability is a FIRST-CLASS ROW of this bench, per
*    CLAUDE.md: td_od01 is deliberately an overdrive small enough to sit
*    inside the near-metastable region.
*
* 3. Switching energy per decision and the static current, for the power row.
*
* THE OVERDRIVE LADDER (standalone; no CDAC and no LSB to inherit).
*   dv_big   50 mV    the overdrive README.md's decision-time row is stated at
*   dv_mid    1 mV    a small overdrive, deep in the logarithmic regime
*   dv_tiny   0.1 mV  ~1 decade smaller again: the tau lever arm, and a
*                     near-metastable probe
* tau is extracted from the (mid, tiny) pair because both are inside the
* logarithmic region; the 50 mV rung is large-signal and sets t0.
*
* EVERY INSTANCE DECIDES BOTH WAYS, AND THAT IS WHAT MAKES THE MEASUREMENT
* ROBUST. Each input is a PWL that is NEGATIVE for the first strobe and
* POSITIVE for the second. The delay is therefore measured on a strobe where
* the output must actively flip a latch holding the OPPOSITE answer, so it
* cannot depend on which state the output happened to start in.
*
* TIMING THRESHOLDS ARE SUPPLY-NORMALIZED. Every delay triggers on a node
* divided by its own supply and crossed at 0.5 (the Bclkn/Bd*n sources
* below). A fixed absolute threshold would turn the +/-10 % supply axis into
* a measurement artefact.
*
* MISMATCH IS OFF (the plain `mos` corner set), deliberately. Regeneration
* time and offset are separable and are budgeted separately: offset shifts
* the input at which the decision flips (measured in
* sim/comparator-offset-mc/), while tau sets how fast a given overdrive
* resolves.
*
* This subckt-level behaviour (params g_reg/c_reg/... inside
* comparator_dut_latch) is supply-independent by construction -- every
* threshold there is expressed relative to v(vdd,vss) -- so the timing
* windows below (10 ns strobe spacing, 20 ns input flip) needed no rescaling
* for SG13G2's 1.2 V rail versus gf180-comparator's 3.3 V-class one; both
* PDKs' placeholder latches share the same tau = c_reg/(2*g_reg) ~ 50 ps by
* construction, confirmed by direct simulation during issue #8.

.param dv_big=50m
.param dv_mid=1m
.param dv_tiny=0.1m
.param t_flip=20n
.param c_route=10f

* ---- supplies --------------------------------------------------------
* Instance A gets its own supply so its switching charge can be integrated
* without the other two instances' current in the same integral.
vsup  vdd  0 dc {vdd_val}
vsupa vdda 0 dc {vdd_val}

* ---- clock: two strobes, decision measured on the second ---------------
vclk clk 0 pulse(0 {vdd_val} 10n 100p 100p 10n 30n)

* ---- common mode -----------------------------------------------------
vcm cm 0 dc {dut_vcm}

* ---- A: 50 mV overdrive, on its own supply ---------------------------
vsa  sa 0 pwl(0 {-dv_big} {t_flip} {-dv_big} {t_flip+1n} {dv_big})
Eapa apa cm sa 0 0.5
Eana ana cm sa 0 -0.5
iba  vdda ibna dc {dut_ib}
Xa   apa ana clk ibna douta doutba vdda 0 comparator_dut

* ---- B: 1 mV overdrive ------------------------------------------------
vsb  sb 0 pwl(0 {-dv_mid} {t_flip} {-dv_mid} {t_flip+1n} {dv_mid})
Eapb apb cm sb 0 0.5
Eanb anb cm sb 0 -0.5
ibb  vdd ibnb dc {dut_ib}
Xb   apb anb clk ibnb doutb doutbb vdd 0 comparator_dut

* ---- C: 0.1 mV overdrive (tau lever arm / metastability probe) --------
vsc  sc 0 pwl(0 {-dv_tiny} {t_flip} {-dv_tiny} {t_flip+1n} {dv_tiny})
Eapc apc cm sc 0 0.5
Eanc anc cm sc 0 -0.5
ibc  vdd ibnc dc {dut_ib}
Xc   apc anc clk ibnc doutc doutbc vdd 0 comparator_dut

* ---- supply-normalized probes ----------------------------------------
Bclkn clkn 0 v = 'v(clk)/v(vdd)'
Bdan  dan  0 v = 'v(douta)/v(vdda)'
Bdbn  dbn  0 v = 'v(doutb)/v(vdd)'
Bdcn  dcn  0 v = 'v(doutc)/v(vdd)'
