* Netlist snapshot for record 20260910-232833-8148438 -- exactly what was simulated.
* DUT: placeholder-v1 (placeholder), sim/dut/placeholder_comparator.spice
* Testbench: sim/comparator-regeneration/testbench/tb_regeneration.spice
* ---------------- DUT NETLIST ----------------
* ============================================================================
* PLACEHOLDER DUT -- NOT A DESIGN, NOT A TOPOLOGY PROPOSAL
* ============================================================================
*
* This netlist exists for exactly one reason: so that sim/'s harness, its
* corner grid, its evidence-record format and its four experiment benches can
* be proven to run end to end BEFORE this repo's comparator topology has been
* decided. That decision is spec/porting-plan.md next step 1 and is a
* separate decision record; it is explicitly out of scope for the harness
* work (issue #8).
*
* Consequences, stated so nobody has to infer them:
*
*   - NOTHING HERE IS SIZED. The devices are round numbers picked by
*     inspection to give a converging operating point at the SG13G2 LV rail
*     (1.2 V +/-10%). No gm/ID study, no noise budget, no offset budget went
*     into any of them.
*   - NO NUMBER MEASURED AGAINST THIS DUT SUBSTANTIATES A SPEC ROW.
*     sim/dut.json declares provenance "placeholder", which makes every
*     record the harness writes against it carry a banner saying so.
*   - THIS IS NOT gf180-comparator's PLACEHOLDER, PORTED. It is this repo's
*     own stub, on SG13G2's LV devices (sg13_lv_nmos/sg13_lv_pmos), at this
*     repo's own supply. spec/porting-plan.md ports gf180-sar-adc's
*     testbench METHODOLOGY, not any topology, sizing, or numbers -- and
*     CLAUDE.md's two-PDK-twin note is about keeping the BENCH definitions
*     structurally identical to gf180-comparator's, not about sharing a DUT.
*   - THE FRONT-END LOAD IS AN IDEAL RESISTOR (plain SPICE `R`), not a PDK
*     resistor subckt. SG13G2's PDK resistors (rsil/rhigh/rppd) DO carry
*     real per-instance local mismatch (confirmed against the installed
*     checkout: resistors_mod_mismatch.lib's `nsmm_rsh`/`nsmm_w`/`nsmm_l`
*     agauss() terms, gated by the same `mm_ok` convention as the LV MOS
*     devices) -- unlike gf180mcu's resistor models, which hard-code their
*     mismatch coefficient to zero. Binding a real PDK resistor here would
*     therefore make a load-mismatch contribution part of this bench's
*     Monte Carlo whether or not that was an intentional design choice, so
*     it is deliberately deferred: sim/harness/corners.py has no `res`
*     family or resistor-dominated corner pair yet (see its module
*     docstring "extension point"), and this placeholder does not need one.
*     The decision stage below is BEHAVIOURAL and therefore commits to no
*     transistor topology at all.
*
* When design/comparator.sch (or its netlist) lands, point sim/dut.json at it
* and re-run. Nothing else in sim/ changes.
*
* Interface contract: sim/dut/README.md.
* Parameters supplied by the harness: dut_ib, dut_vcm, vdd_val, vdd_nom,
* temp_c (sim/harness/runner.py compose_deck).
* ============================================================================

* ---------------------------------------------------------------------------
* comparator_dut_analog -- the DC-resolvable front end.
*
* Exposed as its own subckt because two of the four experiments (offset-MC
* and preamp-noise) are small-signal analyses about a DC operating point.
* See sim/dut/README.md "Why there are two subckts".
*
* Simple NMOS-input pair on sg13_lv_nmos, 1:1 tail mirror, ideal resistor
* loads. w/l are round numbers within the LV device's usual range
* (default w=0.35u l=0.34u -- see the installed checkout's
* sg13g2_moslv_mod.lib). Do not read intent into them.
* ---------------------------------------------------------------------------
.subckt comparator_dut_analog vinp vinn ibias aop aon vdd vss
* 1:1 NMOS current mirror; ibias is forced into the diode branch.
Xmb  ibias ibias vss vss sg13_lv_nmos w=10u l=0.5u ng=1 m=1
Xmt  atail ibias vss vss sg13_lv_nmos w=10u l=0.5u ng=1 m=1
* Input pair. The device whose gate is vinp drives the INVERTING node aon,
* so v(aop) - v(aon) = +A_v * (v(vinp) - v(vinn)).
Xmip aon vinp atail vss sg13_lv_nmos w=20u l=0.5u ng=1 m=1
Xmin aop vinn atail vss sg13_lv_nmos w=20u l=0.5u ng=1 m=1
* Ideal resistor loads. NOT a PDK resistor subckt -- see this file's header
* "THE FRONT-END LOAD IS AN IDEAL RESISTOR" for why.
Rlp vdd aop 20k
Rln vdd aon 20k
.ends comparator_dut_analog

* ---------------------------------------------------------------------------
* comparator_dut_latch -- BEHAVIOURAL regenerative decision stage.
*
* Deliberately behavioural. A transistor-level latch here would be a topology
* choice, and the topology decision is out of scope. What this models is only
* the *observable contract* every latched comparator has, so that the
* regeneration and kickback benches have something real to measure:
*
*   clk low   -> reset: both regeneration nodes pulled to mid-rail
*   clk high  -> evaluate: dv/dt = dv/tau + (input injection), i.e. the
*                exponential regeneration law t = t0 + tau*ln(V/(A*Vin))
*                the regeneration bench extracts tau from
*   output    -> held between decisions, flipping only once the regeneration
*                nodes have separated past an absolute threshold (an SR
*                latch's behaviour, not a differential zero-crossing)
*
* c_fb IS THE PART THAT MATTERS FOR KICKBACK and it is an explicit, declared
* stand-in: a real latch's input pair couples its rail-to-rail regeneration
* nodes back to its inputs through C_gd. Modelling that as an explicit 5 fF
* per side means the kickback bench measures a real path (regeneration node
* -> front-end output -> input-pair C_gd -> input node) instead of reporting
* a fictitious zero. The VALUE is a placeholder like everything else here.
*
* Ported structurally, unchanged in substance, from gf180-comparator's own
* placeholder_comparator.spice: this subckt is PDK-independent (it names no
* device model at all, only ideal behavioural sources referenced to
* v(vdd,vss)), so it needed no adaptation for SG13G2's 1.2 V rail -- every
* threshold below is expressed as a fraction of the supplied vdd/vss, not as
* an absolute volt figure.
* ---------------------------------------------------------------------------
.subckt comparator_dut_latch inp inn clk dout doutb vdd vss
.param g_reg=5m
.param c_reg=500f
.param g_in=5m
.param v_lim=0.4
.param c_fb=5f
.param g_clamp=1
.param r_hold=200
.param c_hold=100f
.param v_th=0.8
.param v_sharp=0.1
.param r_rst=100
* Clock enable, smoothed so the B-source expressions stay differentiable.
Ben  ken 0 v = '0.5*(1+tanh((v(clk)-0.5*v(vdd,vss))/0.05))'
Cqp  qp 0 {c_reg}
Cqn  qn 0 {c_reg}
* Positive feedback (tanh-limited) plus input injection. tau = c_reg/(2*g_reg).
Bqp  0 qp i = 'v(ken)*( g_reg*v_lim*tanh((v(qp)-v(qn))/v_lim) + g_in*(v(inp)-v(inn)) )'
Bqn  0 qn i = '-v(ken)*( g_reg*v_lim*tanh((v(qp)-v(qn))/v_lim) + g_in*(v(inp)-v(inn)) )'
* Reset to mid-rail while clk is low.
Brp  0 qp i = '(1-v(ken))*(0.5*v(vdd,vss)-v(qp))/r_rst'
Brn  0 qn i = '(1-v(ken))*(0.5*v(vdd,vss)-v(qn))/r_rst'
* Rail clamps -- the regeneration nodes are supply-bounded, like real ones.
Bcp  qp 0 i = 'g_clamp*(max(v(qp)-v(vdd),0)+min(v(qp)-v(vss),0))'
Bcn  qn 0 i = 'g_clamp*(max(v(qn)-v(vdd),0)+min(v(qn)-v(vss),0))'
* Latch input pair C_gd, explicit. This is the kickback path (see header).
Ckp  qp inp {c_fb}
Ckn  qn inn {c_fb}
* Output hold. Tracks the decision only once |v(qp)-v(qn)| passes v_th, so
* the output delay is a real function of overdrive rather than of the moment
* the differential crosses zero. Rh keeps the node non-floating for `op`.
Ch   h 0 {c_hold}
Rh   h vss 1G
Bh   0 h i = 'v(ken)*0.5*(1+tanh((abs(v(qp)-v(qn))-v_th)/v_sharp))*(v(vdd,vss)*0.5*(1+tanh((v(qp)-v(qn))/v_sharp))-v(h))/r_hold'
Bdo  dout  0 v = 'min(max(v(h),v(vss)),v(vdd))'
Bdob doutb 0 v = 'v(vdd)-min(max(v(h),v(vss)),v(vdd))'
.ends comparator_dut_latch

* ---------------------------------------------------------------------------
* comparator_dut -- the full clocked comparator the transient benches drive.
* ---------------------------------------------------------------------------
.subckt comparator_dut vinp vinn clk ibias dout doutb vdd vss
Xa vinp vinn ibias aop aon vdd vss comparator_dut_analog
Xl aop aon clk dout doutb vdd vss comparator_dut_latch
.ends comparator_dut

* ---------------- TESTBENCH FRAGMENT ----------------
* tb_regeneration -- decision time versus input overdrive, the regeneration
* time constant tau extracted from it, and the switching energy per decision.
*
* Netlist FRAGMENT. The harness supplies the models, the corner .lib
* section, .temp, the DUT netlist, the .control block and .end
* (sim/harness/README.md). Parameters from the harness: vdd_val, vdd_nom,
* temp_c, dut_ib, dut_vcm.
*
* METHODOLOGY PORTED FROM gf180-comparator/sim/comparator-regeneration/
* (itself ported from gf180-sar-adc) -- see this experiment's README.md for
* the full transfer/non-transfer list.
*
* WHAT THIS ANSWERS
*
* 1. Is the decision complete inside the budget at the WORST PVT corner,
*    rather than at a typical-corner estimate? README.md's decision-time row
*    is stated at 50 mV overdrive, so 50 mV is the primary rung of the
*    ladder below.
*
* 2. The regeneration time constant tau, EXTRACTED rather than assumed. A
*    regenerative latch resolves in t = t0 + tau*ln(V_logic/(A_v*V_in)), so
*    the delay difference between two KNOWN overdrives gives tau directly:
*        tau = (t(V_small) - t(V_large)) / ln(V_large/V_small)
*    Everything downstream -- the metastability window -- is computed from
*    tau, so tau is the quantity that must be measured, not the delay at one
*    overdrive. Metastability is a FIRST-CLASS ROW of this bench, per
*    CLAUDE.md: td_od01 is deliberately an overdrive small enough to sit
*    inside the near-metastable region.
*
* 3. Switching energy per decision and the static current, for the power row.
*
* THE OVERDRIVE LADDER (standalone; no CDAC and no LSB to inherit).
*   dv_big   50 mV    the overdrive README.md's decision-time row is stated at
*   dv_mid    1 mV    a small overdrive, deep in the logarithmic regime
*   dv_tiny   0.1 mV  ~1 decade smaller again: the tau lever arm, and a
*                     near-metastable probe
* tau is extracted from the (mid, tiny) pair because both are inside the
* logarithmic region; the 50 mV rung is large-signal and sets t0.
*
* EVERY INSTANCE DECIDES BOTH WAYS, AND THAT IS WHAT MAKES THE MEASUREMENT
* ROBUST. Each input is a PWL that is NEGATIVE for the first strobe and
* POSITIVE for the second. The delay is therefore measured on a strobe where
* the output must actively flip a latch holding the OPPOSITE answer, so it
* cannot depend on which state the output happened to start in.
*
* TIMING THRESHOLDS ARE SUPPLY-NORMALIZED. Every delay triggers on a node
* divided by its own supply and crossed at 0.5 (the Bclkn/Bd*n sources
* below). A fixed absolute threshold would turn the +/-10 % supply axis into
* a measurement artefact.
*
* MISMATCH IS OFF (the plain `mos` corner set), deliberately. Regeneration
* time and offset are separable and are budgeted separately: offset shifts
* the input at which the decision flips (measured in
* sim/comparator-offset-mc/), while tau sets how fast a given overdrive
* resolves.
*
* This subckt-level behaviour (params g_reg/c_reg/... inside
* comparator_dut_latch) is supply-independent by construction -- every
* threshold there is expressed relative to v(vdd,vss) -- so the timing
* windows below (10 ns strobe spacing, 20 ns input flip) needed no rescaling
* for SG13G2's 1.2 V rail versus gf180-comparator's 3.3 V-class one; both
* PDKs' placeholder latches share the same tau = c_reg/(2*g_reg) ~ 50 ps by
* construction, confirmed by direct simulation during issue #8.

.param dv_big=50m
.param dv_mid=1m
.param dv_tiny=0.1m
.param t_flip=20n
.param c_route=10f

* ---- supplies --------------------------------------------------------
* Instance A gets its own supply so its switching charge can be integrated
* without the other two instances' current in the same integral.
vsup  vdd  0 dc {vdd_val}
vsupa vdda 0 dc {vdd_val}

* ---- clock: two strobes, decision measured on the second ---------------
vclk clk 0 pulse(0 {vdd_val} 10n 100p 100p 10n 30n)

* ---- common mode -----------------------------------------------------
vcm cm 0 dc {dut_vcm}

* ---- A: 50 mV overdrive, on its own supply ---------------------------
vsa  sa 0 pwl(0 {-dv_big} {t_flip} {-dv_big} {t_flip+1n} {dv_big})
Eapa apa cm sa 0 0.5
Eana ana cm sa 0 -0.5
iba  vdda ibna dc {dut_ib}
Xa   apa ana clk ibna douta doutba vdda 0 comparator_dut

* ---- B: 1 mV overdrive ------------------------------------------------
vsb  sb 0 pwl(0 {-dv_mid} {t_flip} {-dv_mid} {t_flip+1n} {dv_mid})
Eapb apb cm sb 0 0.5
Eanb anb cm sb 0 -0.5
ibb  vdd ibnb dc {dut_ib}
Xb   apb anb clk ibnb doutb doutbb vdd 0 comparator_dut

* ---- C: 0.1 mV overdrive (tau lever arm / metastability probe) --------
vsc  sc 0 pwl(0 {-dv_tiny} {t_flip} {-dv_tiny} {t_flip+1n} {dv_tiny})
Eapc apc cm sc 0 0.5
Eanc anc cm sc 0 -0.5
ibc  vdd ibnc dc {dut_ib}
Xc   apc anc clk ibnc doutc doutbc vdd 0 comparator_dut

* ---- supply-normalized probes ----------------------------------------
Bclkn clkn 0 v = 'v(clk)/v(vdd)'
Bdan  dan  0 v = 'v(douta)/v(vdda)'
Bdbn  dbn  0 v = 'v(doutb)/v(vdd)'
Bdcn  dcn  0 v = 'v(doutc)/v(vdd)'
