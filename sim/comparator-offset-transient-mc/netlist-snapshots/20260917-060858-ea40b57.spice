* Netlist snapshot for record 20260917-060858-ea40b57 -- exactly what was simulated.
* DUT: comparator-dr0001 (schematic), design/comparator.spice
* Testbench: sim/comparator-offset-transient-mc/testbench/tb_offset_transient_mc.spice
* ---------------- DUT NETLIST ----------------
* ============================================================================
* sg13g2-comparator -- DERIVED NETLIST.  DO NOT EDIT BY HAND.
* ============================================================================
*
* Generated from the xschem sources in design/ by:
*
*     python3 design/netlist.py
*
* The schematics are the source of record:
*
*   design/comparator.sch              the design -- a single-tail StrongARM
*                                      dynamic latch (spec/decision-records/
*                                      0001-comparator-topology.md), plus the
*                                      isolation inverters and NOR SR latch
*                                      that make its outputs HELD between
*                                      strobes as the interface contract
*                                      requires
*   design/comparator_dut.sch          contract wrapper: tail-bias reference
*                                      on the `ibias` pin + the core
*   design/comparator_dut_latch.sch    contract wrapper: the core with its
*                                      tail-bias node tied to vdd
*   design/comparator_dut_analog.sch   the LOOP-BROKEN reduced sub-model --
*                                      an offset/noise LOWER BOUND, not the
*                                      design's front end.  Read
*                                      design/README.md before quoting any
*                                      number measured against it.
*
* Interface contract: sim/dut/README.md.  Asserted at generation time by
* design/netlist.py (against sim/harness/dut.py's own REQUIRED_SUBCKTS) and
* again at load time by the harness.
*
* Parameters supplied by the harness, not by this file: dut_ib, dut_vcm,
* vdd_val, vdd_nom, temp_c (sim/harness/runner.py compose_deck).  This file
* deliberately contains no .include / .lib / .temp / .control / .endc / .end.
* ============================================================================

.subckt comparator vinp vinn clk vbias dout doutb vdd vss
*.iopin vinp
*.iopin vinn
*.iopin clk
*.iopin vbias
*.iopin dout
*.iopin doutb
*.iopin vdd
*.iopin vss
XMT tmid vbias vss vss sg13_lv_nmos w=40u l=0.5u ng=1 m=1
XMSW tail clk tmid vss sg13_lv_nmos w=40u l=0.13u ng=1 m=1
XM1 np vinp tail vss sg13_lv_nmos w=12u l=0.34u ng=1 m=1
XM2 nn vinn tail vss sg13_lv_nmos w=12u l=0.34u ng=1 m=1
XM3 ln lp np vss sg13_lv_nmos w=3u l=0.13u ng=1 m=1
XM4 lp ln nn vss sg13_lv_nmos w=3u l=0.13u ng=1 m=1
XM5 ln lp vdd vdd sg13_lv_pmos w=3u l=0.13u ng=1 m=1
XM6 lp ln vdd vdd sg13_lv_pmos w=3u l=0.13u ng=1 m=1
XM7 ln clk vdd vdd sg13_lv_pmos w=6u l=0.13u ng=1 m=1
XM8 lp clk vdd vdd sg13_lv_pmos w=6u l=0.13u ng=1 m=1
XM9 np clk vdd vdd sg13_lv_pmos w=3u l=0.13u ng=1 m=1
XM10 nn clk vdd vdd sg13_lv_pmos w=3u l=0.13u ng=1 m=1
XMIAP lnb ln vdd vdd sg13_lv_pmos w=3u l=0.13u ng=1 m=1
XMIAN lnb ln vss vss sg13_lv_nmos w=1.5u l=0.13u ng=1 m=1
XMIBP lpb lp vdd vdd sg13_lv_pmos w=3u l=0.13u ng=1 m=1
XMIBN lpb lp vss vss sg13_lv_nmos w=1.5u l=0.13u ng=1 m=1
XMNAP1 na lnb vdd vdd sg13_lv_pmos w=4u l=0.13u ng=1 m=1
XMNAP2 doutb dout na vdd sg13_lv_pmos w=4u l=0.13u ng=1 m=1
XMNAN1 doutb lnb vss vss sg13_lv_nmos w=1.5u l=0.13u ng=1 m=1
XMNAN2 doutb dout vss vss sg13_lv_nmos w=1.5u l=0.13u ng=1 m=1
XMNBP1 nb lpb vdd vdd sg13_lv_pmos w=4u l=0.13u ng=1 m=1
XMNBP2 dout doutb nb vdd sg13_lv_pmos w=4u l=0.13u ng=1 m=1
XMNBN1 dout lpb vss vss sg13_lv_nmos w=1.5u l=0.13u ng=1 m=1
XMNBN2 dout doutb vss vss sg13_lv_nmos w=1.5u l=0.13u ng=1 m=1
.ends

.subckt comparator_dut_analog vinp vinn ibias aop aon vdd vss
*.iopin vinp
*.iopin vinn
*.iopin ibias
*.iopin aop
*.iopin aon
*.iopin vdd
*.iopin vss
XMBA ibias ibias vss vss sg13_lv_nmos w=10u l=0.5u ng=1 m=1
XMTA tmid ibias vss vss sg13_lv_nmos w=40u l=0.5u ng=1 m=1
XMSWA tail vdd tmid vss sg13_lv_nmos w=40u l=0.13u ng=1 m=1
XM1A aon vinp tail vss sg13_lv_nmos w=12u l=0.34u ng=1 m=1
XM2A aop vinn tail vss sg13_lv_nmos w=12u l=0.34u ng=1 m=1
XM5A aon aon vdd vdd sg13_lv_pmos w=3u l=0.13u ng=1 m=1
XM6A aop aop vdd vdd sg13_lv_pmos w=3u l=0.13u ng=1 m=1
.ends

.subckt comparator_dut_latch inp inn clk dout doutb vdd vss
*.iopin inp
*.iopin inn
*.iopin clk
*.iopin dout
*.iopin doutb
*.iopin vdd
*.iopin vss
x1 inp inn clk vdd dout doutb vdd vss comparator
.ends

.subckt comparator_dut vinp vinn clk ibias dout doutb vdd vss
*.iopin vinp
*.iopin vinn
*.iopin clk
*.iopin ibias
*.iopin dout
*.iopin doutb
*.iopin vdd
*.iopin vss
XMB ibias ibias vss vss sg13_lv_nmos w=10u l=0.5u ng=1 m=1
x1 vinp vinn clk ibias dout doutb vdd vss comparator
.ends

* ---------------- TESTBENCH FRAGMENT ----------------
* tb_offset_transient_mc -- transient Monte-Carlo input-referred offset of
* the WHOLE latch (strobe -> decision), not the loop-broken
* comparator_dut_analog reduced sub-model comparator-offset-mc measures.
*
* Netlist FRAGMENT. The harness supplies the models, the corner .lib
* section, .temp, the DUT netlist, the .control block and .end
* (sim/harness/README.md). Parameters from the harness: vdd_val, vdd_nom,
* temp_c, dut_ib, dut_vcm.
*
* METHOD (full rationale in this experiment's README.md): a single
* comparator_dut instance (design/comparator.spice's actual, regenerative
* topology -- the sim/dut/README.md contract's `vinp vinn clk ibias dout
* doutb vdd vss` subckt, NOT comparator_dut_analog) is driven by a
* DIGITAL STAIRCASE differential input riding on the periodic strobe this
* file's clock generates. Each of N_LEVELS steps is held for one full
* strobe cycle (comparator-regeneration's own proven 30 ns cadence: 10 ns
* reset, 10 ns evaluate, 10 ns settle before the next step), so every
* level is a completely independent decision -- reset between strobes
* clears the prior decision, exactly as comparator-regeneration's own
* "every instance decides both ways" property already demonstrates for
* this DUT. tb.json's .control block samples the held, supply-normalized
* output once per level, well after that level's strobe has closed, and
* turns the resulting near-binary staircase into one offset estimate per
* Monte-Carlo draw (see tb.json's "evidence" block for the summation
* method and its rationale).
*
* WHY A STAIRCASE, NOT A BISECTION SEARCH. A per-draw bisection would need
* several `tran` sub-runs per draw while holding that draw's mismatch
* fixed -- but SG13G2's mismatch is only re-drawn on `reset`
* (sim/device-mismatch-confirm/README.md, sim/comparator-offset-mc's own
* method), and ngspice's `tran` command does not restart at t=0 without an
* intervening `reset`. A single staircase transient per draw sidesteps
* that entirely: one `reset` (one mismatch draw), one `tran` covering
* every level, exactly mirroring the "one instance, N sequential strobes"
* pattern comparator-regeneration already validates for this DUT.
*
* WHY THIS ANSWERS THE OFFSET QUESTION COMPLETELY, UNLIKE
* comparator-offset-mc. comparator_dut is the actual DR-0001 topology,
* strobe and all -- there is no diode-connected substitution, so the
* regenerative loop's own local mismatch (the cross-coupled inverter
* pair, the reset devices, the tail) is exercised on every decision, not
* excluded by construction the way comparator_dut_analog excludes it.
*
* STANDALONE STIMULUS, SINGLE COMMON MODE. Unlike comparator-offset-mc
* (which also sweeps a +/-50 mV common-mode band), this bench sweeps only
* the differential axis at the DUT's own dut_vcm -- the common-mode
* dependence of the whole-latch offset is a separate, not-yet-specified
* extension (see this experiment's README.md), deliberately out of scope
* here so the transient grid stays inside the harness's per-point timeout.
*
* MISMATCH IS A CORNER SELECTION, same convention as comparator-offset-mc:
* the mos_mismatch corner set IS the Monte-Carlo switch (see
* sim/harness/corners.py's module docstring); this fragment sets nothing
* mismatch-related itself.

.param c_route=10f
.param tstep_last=48m

* ---- supply ------------------------------------------------------------
vsup vdd 0 dc {vdd_val}

* ---- common mode + staircase differential stimulus ----------------------
* vd is a PWL staircase, one flat step per strobe cycle -- the breakpoint
* list is generated by tb.json's harness-independent methodology notes and
* pasted here as a literal PWL (see README.md "Reproducing the deck" for
* the generator script). 33 levels, -48 mV to +48 mV, 3 mV/step, 30 ns/step.
vcm cm 0 dc {dut_vcm}
vd   vd 0 pwl(
+ 0.0000n -0.048 29.8000n -0.048 30.0000n -0.045 59.8000n -0.045
+ 60.0000n -0.042 89.8000n -0.042 90.0000n -0.039 119.8000n -0.039
+ 120.0000n -0.036 149.8000n -0.036 150.0000n -0.033 179.8000n -0.033
+ 180.0000n -0.03 209.8000n -0.03 210.0000n -0.027 239.8000n -0.027
+ 240.0000n -0.024 269.8000n -0.024 270.0000n -0.021 299.8000n -0.021
+ 300.0000n -0.018 329.8000n -0.018 330.0000n -0.015 359.8000n -0.015
+ 360.0000n -0.012 389.8000n -0.012 390.0000n -0.009 419.8000n -0.009
+ 420.0000n -0.006 449.8000n -0.006 450.0000n -0.003 479.8000n -0.003
+ 480.0000n 0 509.8000n 0 510.0000n 0.003 539.8000n 0.003
+ 540.0000n 0.006 569.8000n 0.006 570.0000n 0.009 599.8000n 0.009
+ 600.0000n 0.012 629.8000n 0.012 630.0000n 0.015 659.8000n 0.015
+ 660.0000n 0.018 689.8000n 0.018 690.0000n 0.021 719.8000n 0.021
+ 720.0000n 0.024 749.8000n 0.024 750.0000n 0.027 779.8000n 0.027
+ 780.0000n 0.03 809.8000n 0.03 810.0000n 0.033 839.8000n 0.033
+ 840.0000n 0.036 869.8000n 0.036 870.0000n 0.039 899.8000n 0.039
+ 900.0000n 0.042 929.8000n 0.042 930.0000n 0.045 959.8000n 0.045
+ 960.0000n 0.048 989.8000n 0.048 990.0000n 0.048
+ )
Eap ap cm vd 0 0.5
Ean an cm vd 0 -0.5

* ---- clock: one strobe per 30 ns step, decision measured after each ----
vclk clk 0 pulse(0 {vdd_val} 10n 100p 100p 10n 30n)

* ---- device under test (whole latch; see sim/dut/README.md) ------------
ib   vdd ibn dc {dut_ib}
Xa   ap an clk ibn dout doutb vdd 0 comparator_dut

* Routing allowance on the decision output, matching the small allowance
* the other three benches carry on their own output/front-end nodes.
Cwd dout 0 {c_route}

* Supply-normalized decision probe -- read once per level by tb.json's
* per-level `meas tran dlevK find v(doutn) at=...` lines.
Bdoutn doutn 0 v = 'v(dout)/v(vdd)'
