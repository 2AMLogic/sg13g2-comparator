* device-mismatch-confirm: SG13G2 LV sg13_lv_nmos pair -- per-instance
* local-mismatch probe (issue #6, gap-to-T1 tracker #3 item 6, porting-plan
* next step 2). Generated from
* sim/device-mismatch-confirm/testbench/tb_lv_mismatch_pair.spice.tmpl
* by sim/device-mismatch-confirm/run_mismatch_check.sh -- do not hand-edit
* a generated corners/*.spice file, edit this template and re-run the
* check. Full methodology rationale is in
* sim/device-mismatch-confirm/README.md.
*
* Two nominally identical sg13_lv_nmos instances (same w/l/ng/m), each
* diode-connected (gate=drain) and biased at Id=10u via an ideal
* current source -- the exact same single-device fixture topology as the
* PDK's own reference Monte Carlo testcase
* (libs.tech/xschem/sg13g2_tests/mc_lv_nmos_cs_loop.sch,
* libs.tech/xschem/simulations/scripts/MC_mos.py), instantiated TWICE in
* one netlist so the two devices' Vgs values can be directly differenced
* per Monte-Carlo draw: dVgs = Vgs(M2) - Vgs(M1) is the local-mismatch
* signature under test (zero would mean no per-instance mismatch is
* modelled; nonzero, seed-varying spread would confirm it is).
*
* Corner under test: mos_tt_mismatch (see
* sim/device-mismatch-confirm/corners/README.md for what each of this
* PDK's cornerMOSlv.lib corners means).
* PDK: ihp-sg13g2 /Users/rwalters/share/pdk (see sim/pdk.json for the pinned release)
* OSDI models: /Users/rwalters/share/pdk/ihp-sg13g2/libs.tech/ngspice/osdi (psp103.osdi backs the sg13_lv_nmos/
*   sg13_lv_pmos PSP103 compact model both devices below instantiate; see
*   sim/device-mismatch-confirm/README.md "Reproducing" for the build
*   recipe if it is not already present there)
* rndseed: 1234 (fixed once at the top of the .control loop below, so
*   the whole N-run sweep is reproducible from this one committed value)
* N runs: 30

.param mm_ok=1

.lib "/Users/rwalters/share/pdk/ihp-sg13g2/libs.tech/ngspice/models/cornerMOSlv.lib" mos_tt_mismatch

* M1 -- diode-connected, Id=10u pulled from ground into node vgs1,
* down through the device back to ground (bulk tied to source, same
* single-device probe convention this PDK's own mc_lv_*_cs_loop.sch uses).
I1 0 vgs1 10u
XM1 vgs1 vgs1 0 0 sg13_lv_nmos l=0.45u w=1.0u ng=1 m=1 mm_ok=1

* M2 -- nominally identical to M1 (same subckt, same w/l/ng/m), same bias
* topology, independent random draw under the mismatch corner.
I2 0 vgs2 10u
XM2 vgs2 vgs2 0 0 sg13_lv_nmos l=0.45u w=1.0u ng=1 m=1 mm_ok=1

.control
pre_osdi /Users/rwalters/share/pdk/ihp-sg13g2/libs.tech/ngspice/osdi/psp103.osdi
set rndseed=1234
let nruns = 30
let run = 0
set curplot=new
set scratch=$curplot
setplot $scratch
let vgs1_arr = unitvec(nruns)
let vgs2_arr = unitvec(nruns)

* Monte Carlo loop: op-point, stash both nodes' voltages into this run's
* scratch plot, THEN reset (forces the circuit to be rebuilt from the
* netlist text, which is what makes every agauss()-bound delvto/factuo/w/l
* parameter re-draw on the next `op` -- confirmed empirically during issue
* #6's investigation: dropping `reset` freezes the same draw every
* iteration). This is the same reset-per-iteration idiom the PDK's own
* mc_lv_nmos_cs_loop.sch / mc_lv_pmos_cs_loop.sch ship, adapted here from
* a single-device sweep to a two-device DIFFERENCE sweep.
dowhile run < nruns
  op
  set dt=$curplot
  setplot $scratch
  let vgs1_arr[run] = \{$dt\}.vgs1
  let vgs2_arr[run] = \{$dt\}.vgs2
  setplot $dt
  reset
  let run = run + 1
end

setplot $scratch
let dvgs_arr = vgs2_arr - vgs1_arr
wrdata /Users/rwalters/GitHub/sg13g2-comparator/.loom/worktrees/issue-6/sim/device-mismatch-confirm/corners/20260909-052553/nmos-mismatch.csv vgs1_arr vgs2_arr dvgs_arr
.endc
.end
