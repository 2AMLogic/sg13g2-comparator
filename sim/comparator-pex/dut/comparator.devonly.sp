* GENERATED by sim/comparator-pex/make_devonly.py (issue #191) -- DIAGNOSTIC leg,
* not compliance evidence. Source: layout/comparator/comparator.pex.spice
* sha256 9bd443bec862e96a3cae3bf3651506e75c8ceeb6a534789ef794c5defe58980a
* 64 extracted devices, model/W/L/AS/AD/PS/PD verbatim; 252 terminal series
* R collapsed to parent nets; 16 ground C and 52 coupling C removed;
* 1 DC substrate tie retained (no routing parasitic).
.GLOBAL vsubs
.subckt comparator clk dout doutb vbias vdd vinn vinp vss
X$1 tmid vbias vss vss sg13_lv_nmos L=0.5U W=5U AS=2.5P AD=1.25P PS=11U PD=5.5U
X$2 vss vbias tmid vss sg13_lv_nmos L=0.5U W=5U AS=1.25P AD=1.25P PS=5.5U PD=5.5U
X$3 tmid vbias vss vss sg13_lv_nmos L=0.5U W=5U AS=1.25P AD=1.25P PS=5.5U PD=5.5U
X$4 vss vbias tmid vss sg13_lv_nmos L=0.5U W=5U AS=1.25P AD=1.25P PS=5.5U PD=5.5U
X$5 tmid vbias vss vss sg13_lv_nmos L=0.5U W=5U AS=1.25P AD=1.25P PS=5.5U PD=5.5U
X$6 vss vbias tmid vss sg13_lv_nmos L=0.5U W=5U AS=1.25P AD=1.25P PS=5.5U PD=5.5U
X$7 tmid vbias vss vss sg13_lv_nmos L=0.5U W=5U AS=1.25P AD=1.25P PS=5.5U PD=5.5U
X$8 vss vbias tmid vss sg13_lv_nmos L=0.5U W=5U AS=1.25P AD=2.5P PS=5.5U PD=11U
X$9 tail clk tmid vss sg13_lv_nmos L=0.13U W=5U AS=2.5P AD=1.25P PS=11U PD=5.5U
X$10 tmid clk tail vss sg13_lv_nmos L=0.13U W=5U AS=1.25P AD=1.25P PS=5.5U PD=5.5U
X$11 tail clk tmid vss sg13_lv_nmos L=0.13U W=5U AS=1.25P AD=1.25P PS=5.5U PD=5.5U
X$12 tmid clk tail vss sg13_lv_nmos L=0.13U W=5U AS=1.25P AD=1.25P PS=5.5U PD=5.5U
X$13 tail clk tmid vss sg13_lv_nmos L=0.13U W=5U AS=1.25P AD=1.25P PS=5.5U PD=5.5U
X$14 tmid clk tail vss sg13_lv_nmos L=0.13U W=5U AS=1.25P AD=1.25P PS=5.5U PD=5.5U
X$15 tail clk tmid vss sg13_lv_nmos L=0.13U W=5U AS=1.25P AD=1.25P PS=5.5U PD=5.5U
X$16 tmid clk tail vss sg13_lv_nmos L=0.13U W=5U AS=1.25P AD=2.5P PS=5.5U PD=11U
X$17 np vinp tail vss sg13_lv_nmos L=0.34U W=3U AS=1.5P AD=0.75P PS=7U PD=3.5U
X$18 tail vinp np vss sg13_lv_nmos L=0.34U W=3U AS=0.75P AD=1.5P PS=3.5U PD=7U
X$19 nn vinn tail vss sg13_lv_nmos L=0.34U W=3U AS=1.5P AD=0.75P PS=7U PD=3.5U
X$20 tail vinn nn vss sg13_lv_nmos L=0.34U W=3U AS=0.75P AD=1.5P PS=3.5U PD=7U
X$21 nn vinn tail vss sg13_lv_nmos L=0.34U W=3U AS=1.5P AD=0.75P PS=7U PD=3.5U
X$22 tail vinn nn vss sg13_lv_nmos L=0.34U W=3U AS=0.75P AD=1.5P PS=3.5U PD=7U
X$23 np vinp tail vss sg13_lv_nmos L=0.34U W=3U AS=1.5P AD=0.75P PS=7U PD=3.5U
X$24 tail vinp np vss sg13_lv_nmos L=0.34U W=3U AS=0.75P AD=1.5P PS=3.5U PD=7U
X$25 ln lp np vss sg13_lv_nmos L=0.13U W=0.75U AS=0.375P AD=0.1875P PS=2.5U PD=1.25U
X$26 np lp ln vss sg13_lv_nmos L=0.13U W=0.75U AS=0.1875P AD=0.375P PS=1.25U PD=2.5U
X$27 lp ln nn vss sg13_lv_nmos L=0.13U W=0.75U AS=0.375P AD=0.1875P PS=2.5U PD=1.25U
X$28 nn ln lp vss sg13_lv_nmos L=0.13U W=0.75U AS=0.1875P AD=0.375P PS=1.25U PD=2.5U
X$29 lp ln nn vss sg13_lv_nmos L=0.13U W=0.75U AS=0.375P AD=0.1875P PS=2.5U PD=1.25U
X$30 nn ln lp vss sg13_lv_nmos L=0.13U W=0.75U AS=0.1875P AD=0.375P PS=1.25U PD=2.5U
X$31 ln lp np vss sg13_lv_nmos L=0.13U W=0.75U AS=0.375P AD=0.1875P PS=2.5U PD=1.25U
X$32 np lp ln vss sg13_lv_nmos L=0.13U W=0.75U AS=0.1875P AD=0.375P PS=1.25U PD=2.5U
X$33 doutb dout vss vss sg13_lv_nmos L=0.13U W=1.5U AS=0.75P AD=0.375P PS=4U PD=2U
X$34 vss lnb doutb vss sg13_lv_nmos L=0.13U W=1.5U AS=0.375P AD=0.375P PS=2U PD=2U
X$35 lnb ln vss vss sg13_lv_nmos L=0.13U W=1.5U AS=0.375P AD=0.75P PS=2U PD=4U
X$36 vss lp lpb vss sg13_lv_nmos L=0.13U W=1.5U AS=0.75P AD=0.375P PS=4U PD=2U
X$37 dout lpb vss vss sg13_lv_nmos L=0.13U W=1.5U AS=0.375P AD=0.375P PS=2U PD=2U
X$38 vss doutb dout vss sg13_lv_nmos L=0.13U W=1.5U AS=0.375P AD=0.75P PS=2U PD=4U
X$39 ln lp vdd vdd sg13_lv_pmos L=0.13U W=0.75U AS=0.375P AD=0.1875P PS=2.5U PD=1.25U
X$40 vdd lp ln vdd sg13_lv_pmos L=0.13U W=0.75U AS=0.1875P AD=0.375P PS=1.25U PD=2.5U
X$41 lp ln vdd vdd sg13_lv_pmos L=0.13U W=0.75U AS=0.375P AD=0.1875P PS=2.5U PD=1.25U
X$42 vdd ln lp vdd sg13_lv_pmos L=0.13U W=0.75U AS=0.1875P AD=0.375P PS=1.25U PD=2.5U
X$43 lp ln vdd vdd sg13_lv_pmos L=0.13U W=0.75U AS=0.375P AD=0.1875P PS=2.5U PD=1.25U
X$44 vdd ln lp vdd sg13_lv_pmos L=0.13U W=0.75U AS=0.1875P AD=0.375P PS=1.25U PD=2.5U
X$45 ln lp vdd vdd sg13_lv_pmos L=0.13U W=0.75U AS=0.375P AD=0.1875P PS=2.5U PD=1.25U
X$46 vdd lp ln vdd sg13_lv_pmos L=0.13U W=0.75U AS=0.1875P AD=0.375P PS=1.25U PD=2.5U
X$47 np clk vdd vdd sg13_lv_pmos L=0.13U W=1.5U AS=0.75P AD=0.375P PS=4U PD=2U
X$48 vdd clk np vdd sg13_lv_pmos L=0.13U W=1.5U AS=0.375P AD=0.75P PS=2U PD=4U
X$49 ln clk vdd vdd sg13_lv_pmos L=0.13U W=1.5U AS=0.75P AD=0.375P PS=4U PD=2U
X$50 vdd clk ln vdd sg13_lv_pmos L=0.13U W=1.5U AS=0.375P AD=0.75P PS=2U PD=4U
X$51 lp clk vdd vdd sg13_lv_pmos L=0.13U W=1.5U AS=0.75P AD=0.375P PS=4U PD=2U
X$52 vdd clk lp vdd sg13_lv_pmos L=0.13U W=1.5U AS=0.375P AD=0.75P PS=2U PD=4U
X$53 lp clk vdd vdd sg13_lv_pmos L=0.13U W=1.5U AS=0.75P AD=0.375P PS=4U PD=2U
X$54 vdd clk lp vdd sg13_lv_pmos L=0.13U W=1.5U AS=0.375P AD=0.75P PS=2U PD=4U
X$55 ln clk vdd vdd sg13_lv_pmos L=0.13U W=1.5U AS=0.75P AD=0.375P PS=4U PD=2U
X$56 vdd clk ln vdd sg13_lv_pmos L=0.13U W=1.5U AS=0.375P AD=0.75P PS=2U PD=4U
X$57 nn clk vdd vdd sg13_lv_pmos L=0.13U W=1.5U AS=0.75P AD=0.375P PS=4U PD=2U
X$58 vdd clk nn vdd sg13_lv_pmos L=0.13U W=1.5U AS=0.375P AD=0.75P PS=2U PD=4U
X$59 lnb ln vdd vdd sg13_lv_pmos L=0.13U W=3U AS=1.5P AD=1.5P PS=7U PD=7U
X$60 vdd lp lpb vdd sg13_lv_pmos L=0.13U W=3U AS=1.5P AD=1.5P PS=7U PD=7U
X$61 \$25 dout doutb vdd sg13_lv_pmos L=0.13U W=4U AS=2P AD=1P PS=9U PD=4.5U
X$62 vdd lnb \$25 vdd sg13_lv_pmos L=0.13U W=4U AS=1P AD=2P PS=4.5U PD=9U
X$63 \$26 lpb vdd vdd sg13_lv_pmos L=0.13U W=4U AS=2P AD=1P PS=9U PD=4.5U
X$64 dout doutb \$26 vdd sg13_lv_pmos L=0.13U W=4U AS=1P AD=2P PS=4.5U PD=9U
Rvsubs_dctie vsubs 0 1e+12
.ends comparator
