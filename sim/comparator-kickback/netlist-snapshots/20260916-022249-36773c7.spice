* Netlist snapshot for record 20260916-022249-36773c7 -- exactly what was simulated.
* DUT: comparator-dr0001 (schematic), design/comparator.spice
* Testbench: sim/comparator-kickback/testbench/tb_kickback.spice
* ---------------- DUT NETLIST ----------------
* ============================================================================
* sg13g2-comparator -- DERIVED NETLIST.  DO NOT EDIT BY HAND.
* ============================================================================
*
* Generated from the xschem sources in design/ by:
*
*     python3 design/netlist.py
*
* The schematics are the source of record:
*
*   design/comparator.sch              the design -- a single-tail StrongARM
*                                      dynamic latch (spec/decision-records/
*                                      0001-comparator-topology.md), plus the
*                                      isolation inverters and NOR SR latch
*                                      that make its outputs HELD between
*                                      strobes as the interface contract
*                                      requires
*   design/comparator_dut.sch          contract wrapper: tail-bias reference
*                                      on the `ibias` pin + the core
*   design/comparator_dut_latch.sch    contract wrapper: the core with its
*                                      tail-bias node tied to vdd
*   design/comparator_dut_analog.sch   the LOOP-BROKEN reduced sub-model --
*                                      an offset/noise LOWER BOUND, not the
*                                      design's front end.  Read
*                                      design/README.md before quoting any
*                                      number measured against it.
*
* Interface contract: sim/dut/README.md.  Asserted at generation time by
* design/netlist.py (against sim/harness/dut.py's own REQUIRED_SUBCKTS) and
* again at load time by the harness.
*
* Parameters supplied by the harness, not by this file: dut_ib, dut_vcm,
* vdd_val, vdd_nom, temp_c (sim/harness/runner.py compose_deck).  This file
* deliberately contains no .include / .lib / .temp / .control / .endc / .end.
* ============================================================================

.subckt comparator vinp vinn clk vbias dout doutb vdd vss
*.iopin vinp
*.iopin vinn
*.iopin clk
*.iopin vbias
*.iopin dout
*.iopin doutb
*.iopin vdd
*.iopin vss
XMT tmid vbias vss vss sg13_lv_nmos w=40u l=0.5u ng=1 m=1
XMSW tail clk tmid vss sg13_lv_nmos w=40u l=0.13u ng=1 m=1
XM1 np vinp tail vss sg13_lv_nmos w=12u l=0.34u ng=1 m=1
XM2 nn vinn tail vss sg13_lv_nmos w=12u l=0.34u ng=1 m=1
XM3 ln lp np vss sg13_lv_nmos w=3u l=0.13u ng=1 m=1
XM4 lp ln nn vss sg13_lv_nmos w=3u l=0.13u ng=1 m=1
XM5 ln lp vdd vdd sg13_lv_pmos w=3u l=0.13u ng=1 m=1
XM6 lp ln vdd vdd sg13_lv_pmos w=3u l=0.13u ng=1 m=1
XM7 ln clk vdd vdd sg13_lv_pmos w=6u l=0.13u ng=1 m=1
XM8 lp clk vdd vdd sg13_lv_pmos w=6u l=0.13u ng=1 m=1
XM9 np clk vdd vdd sg13_lv_pmos w=3u l=0.13u ng=1 m=1
XM10 nn clk vdd vdd sg13_lv_pmos w=3u l=0.13u ng=1 m=1
XMIAP lnb ln vdd vdd sg13_lv_pmos w=3u l=0.13u ng=1 m=1
XMIAN lnb ln vss vss sg13_lv_nmos w=1.5u l=0.13u ng=1 m=1
XMIBP lpb lp vdd vdd sg13_lv_pmos w=3u l=0.13u ng=1 m=1
XMIBN lpb lp vss vss sg13_lv_nmos w=1.5u l=0.13u ng=1 m=1
XMNAP1 na lnb vdd vdd sg13_lv_pmos w=4u l=0.13u ng=1 m=1
XMNAP2 doutb dout na vdd sg13_lv_pmos w=4u l=0.13u ng=1 m=1
XMNAN1 doutb lnb vss vss sg13_lv_nmos w=1.5u l=0.13u ng=1 m=1
XMNAN2 doutb dout vss vss sg13_lv_nmos w=1.5u l=0.13u ng=1 m=1
XMNBP1 nb lpb vdd vdd sg13_lv_pmos w=4u l=0.13u ng=1 m=1
XMNBP2 dout doutb nb vdd sg13_lv_pmos w=4u l=0.13u ng=1 m=1
XMNBN1 dout lpb vss vss sg13_lv_nmos w=1.5u l=0.13u ng=1 m=1
XMNBN2 dout doutb vss vss sg13_lv_nmos w=1.5u l=0.13u ng=1 m=1
.ends

.subckt comparator_dut_analog vinp vinn ibias aop aon vdd vss
*.iopin vinp
*.iopin vinn
*.iopin ibias
*.iopin aop
*.iopin aon
*.iopin vdd
*.iopin vss
XMBA ibias ibias vss vss sg13_lv_nmos w=10u l=0.5u ng=1 m=1
XMTA tmid ibias vss vss sg13_lv_nmos w=40u l=0.5u ng=1 m=1
XMSWA tail vdd tmid vss sg13_lv_nmos w=40u l=0.13u ng=1 m=1
XM1A aon vinp tail vss sg13_lv_nmos w=12u l=0.34u ng=1 m=1
XM2A aop vinn tail vss sg13_lv_nmos w=12u l=0.34u ng=1 m=1
XM5A aon aon vdd vdd sg13_lv_pmos w=3u l=0.13u ng=1 m=1
XM6A aop aop vdd vdd sg13_lv_pmos w=3u l=0.13u ng=1 m=1
.ends

.subckt comparator_dut_latch inp inn clk dout doutb vdd vss
*.iopin inp
*.iopin inn
*.iopin clk
*.iopin dout
*.iopin doutb
*.iopin vdd
*.iopin vss
x1 inp inn clk vdd dout doutb vdd vss comparator
.ends

.subckt comparator_dut vinp vinn clk ibias dout doutb vdd vss
*.iopin vinp
*.iopin vinn
*.iopin clk
*.iopin ibias
*.iopin dout
*.iopin doutb
*.iopin vdd
*.iopin vss
XMB ibias ibias vss vss sg13_lv_nmos w=10u l=0.5u ng=1 m=1
x1 vinp vinn clk ibias dout doutb vdd vss comparator
.ends

* ---------------- TESTBENCH FRAGMENT ----------------
* tb_kickback -- charge kicked back into the comparator's own input nodes by
* a decision, measured two ways: at the source impedance README.md's kickback
* row is stated at, and against a floating high-impedance source that cannot
* restore the injected charge.
*
* Netlist FRAGMENT. The harness supplies the models, the corner .lib
* section, .temp, the DUT netlist, the .control block and .end
* (sim/harness/README.md). Parameters from the harness: vdd_val, vdd_nom,
* temp_c, dut_ib, dut_vcm.
*
* METHODOLOGY PORTED FROM gf180-comparator/sim/comparator-kickback/ (itself
* ported from gf180-sar-adc) -- see this experiment's README.md for the full
* transfer/non-transfer list.
*
* THE ONE THING THAT MAKES THIS MEASUREMENT REAL: THE SOURCE IMPEDANCE.
* Biasing the inputs from ideal voltage sources restores the injected charge
* instantly and reports ~0 kickback no matter how bad it is; that is the
* standard way this measurement gets faked. Two independent drives are used
* here instead, and BOTH are in the record:
*
*   A -- 1 kohm series source impedance with 100 fF of input-node
*        capacitance. This is the condition README.md's kickback row is
*        stated at. It reports the PEAK transient disturbance.
*
*   B/C -- a 1 pF input node fed through 1 Gohm, i.e. RC = 1 ms against a
*        ~30 ns decision cycle. This reports the RESIDUAL charge left on the
*        node after the decision. B sits at a 1 mV residue and C at 100 mV,
*        so their difference is the SIGNAL-DEPENDENT part of the kickback.
*
* THE RESIDUAL PROBES ARE REFERENCED NEAR ZERO VOLTS, DELIBERATELY. ngspice's
* `meas` returns roughly six significant digits, so differencing two ~1 V
* node levels quantizes the answer at ~1 microvolt -- coarser than the
* residual kickback of a well-isolated input stage. The Bbd/Bcd/Bbc
* behavioural sources below compute the differential (or common-mode-
* referred) node voltage as a signal near 0 V, so `meas` resolves it ~1000x
* finer. Both forms are reported.
*
* MISMATCH IS OFF (the plain `mos` corner set). Kickback and offset are
* separable effects budgeted separately.

.param rsrc=1k
.param cin=100f
.param rfloat=1G
.param cfloat=1p
.param dv_small=1m
.param dv_big=100m
.param t_pre=29n
.param t_post=55n

vsup vdd 0 dc {vdd_val}
vcm  cm 0 dc {dut_vcm}

* One strobe, late enough that every node has settled from the operating
* point before the decision happens.
vclk clk 0 pulse(0 {vdd_val} 30n 100p 100p 10n 30n)

* ---- A: 1 kohm source impedance (README.md's stated condition) --------
vsa  sa 0 dc {dv_small}
Easp asp cm sa 0 0.5
Easn asn cm sa 0 -0.5
Rap  asp apa {rsrc}
Ran  asn ana {rsrc}
Cap  apa 0 {cin}
Can  ana 0 {cin}
iba  vdd ibna dc {dut_ib}
Xa   apa ana clk ibna douta doutba vdd 0 comparator_dut

* ---- B: floating high-Z input, small residue --------------------------
vsb  sb 0 dc {dv_small}
Ebsp bsp cm sb 0 0.5
Ebsn bsn cm sb 0 -0.5
Rbp  bsp bpp {rfloat}
Rbn  bsn bpn {rfloat}
Cbp  bpp 0 {cfloat}
Cbn  bpn 0 {cfloat}
ibb  vdd ibnb dc {dut_ib}
Xb   bpp bpn clk ibnb doutb doutbb vdd 0 comparator_dut

* ---- C: floating high-Z input, large residue --------------------------
vsc  sc 0 dc {dv_big}
Ecsp csp cm sc 0 0.5
Ecsn csn cm sc 0 -0.5
Rcp  csp cpp {rfloat}
Rcn  csn cpn {rfloat}
Ccp  cpp 0 {cfloat}
Ccn  cpn 0 {cfloat}
ibc  vdd ibnc dc {dut_ib}
Xc   cpp cpn clk ibnc doutc doutbc vdd 0 comparator_dut

* ---- near-zero-referenced probes (see header) -------------------------
* ad: instantaneous disturbance of A's + input relative to its own driving
*     source, so the peak is measured against what the node WOULD have been.
Bad ad 0 v = 'v(apa)-v(asp)'
* bd/cd: differential input voltage of the floating instances, a ~1 mV and
*     ~100 mV quantity rather than a ~1 V one.
Bbd bd 0 v = 'v(bpp)-v(bpn)'
Bcd cd 0 v = 'v(cpp)-v(cpn)'
* bc: common-mode displacement of the floating instance, referenced to the
*     bias so it too is a small quantity.
Bbc bc 0 v = '(v(bpp)+v(bpn))/2-v(cm)'

* ---- supply-normalized decision probes --------------------------------
Bdan dan 0 v = 'v(douta)/v(vdd)'
Bdbn dbn 0 v = 'v(doutb)/v(vdd)'
Bdcn dcn 0 v = 'v(doutc)/v(vdd)'
