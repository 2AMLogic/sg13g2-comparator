* Netlist snapshot for record 20260910-232822-8148438 -- exactly what was simulated.
* DUT: placeholder-v1 (placeholder), sim/dut/placeholder_comparator.spice
* Testbench: sim/comparator-preamp-noise/testbench/tb_preamp_noise.spice
* ---------------- DUT NETLIST ----------------
* ============================================================================
* PLACEHOLDER DUT -- NOT A DESIGN, NOT A TOPOLOGY PROPOSAL
* ============================================================================
*
* This netlist exists for exactly one reason: so that sim/'s harness, its
* corner grid, its evidence-record format and its four experiment benches can
* be proven to run end to end BEFORE this repo's comparator topology has been
* decided. That decision is spec/porting-plan.md next step 1 and is a
* separate decision record; it is explicitly out of scope for the harness
* work (issue #8).
*
* Consequences, stated so nobody has to infer them:
*
*   - NOTHING HERE IS SIZED. The devices are round numbers picked by
*     inspection to give a converging operating point at the SG13G2 LV rail
*     (1.2 V +/-10%). No gm/ID study, no noise budget, no offset budget went
*     into any of them.
*   - NO NUMBER MEASURED AGAINST THIS DUT SUBSTANTIATES A SPEC ROW.
*     sim/dut.json declares provenance "placeholder", which makes every
*     record the harness writes against it carry a banner saying so.
*   - THIS IS NOT gf180-comparator's PLACEHOLDER, PORTED. It is this repo's
*     own stub, on SG13G2's LV devices (sg13_lv_nmos/sg13_lv_pmos), at this
*     repo's own supply. spec/porting-plan.md ports gf180-sar-adc's
*     testbench METHODOLOGY, not any topology, sizing, or numbers -- and
*     CLAUDE.md's two-PDK-twin note is about keeping the BENCH definitions
*     structurally identical to gf180-comparator's, not about sharing a DUT.
*   - THE FRONT-END LOAD IS AN IDEAL RESISTOR (plain SPICE `R`), not a PDK
*     resistor subckt. SG13G2's PDK resistors (rsil/rhigh/rppd) DO carry
*     real per-instance local mismatch (confirmed against the installed
*     checkout: resistors_mod_mismatch.lib's `nsmm_rsh`/`nsmm_w`/`nsmm_l`
*     agauss() terms, gated by the same `mm_ok` convention as the LV MOS
*     devices) -- unlike gf180mcu's resistor models, which hard-code their
*     mismatch coefficient to zero. Binding a real PDK resistor here would
*     therefore make a load-mismatch contribution part of this bench's
*     Monte Carlo whether or not that was an intentional design choice, so
*     it is deliberately deferred: sim/harness/corners.py has no `res`
*     family or resistor-dominated corner pair yet (see its module
*     docstring "extension point"), and this placeholder does not need one.
*     The decision stage below is BEHAVIOURAL and therefore commits to no
*     transistor topology at all.
*
* When design/comparator.sch (or its netlist) lands, point sim/dut.json at it
* and re-run. Nothing else in sim/ changes.
*
* Interface contract: sim/dut/README.md.
* Parameters supplied by the harness: dut_ib, dut_vcm, vdd_val, vdd_nom,
* temp_c (sim/harness/runner.py compose_deck).
* ============================================================================

* ---------------------------------------------------------------------------
* comparator_dut_analog -- the DC-resolvable front end.
*
* Exposed as its own subckt because two of the four experiments (offset-MC
* and preamp-noise) are small-signal analyses about a DC operating point.
* See sim/dut/README.md "Why there are two subckts".
*
* Simple NMOS-input pair on sg13_lv_nmos, 1:1 tail mirror, ideal resistor
* loads. w/l are round numbers within the LV device's usual range
* (default w=0.35u l=0.34u -- see the installed checkout's
* sg13g2_moslv_mod.lib). Do not read intent into them.
* ---------------------------------------------------------------------------
.subckt comparator_dut_analog vinp vinn ibias aop aon vdd vss
* 1:1 NMOS current mirror; ibias is forced into the diode branch.
Xmb  ibias ibias vss vss sg13_lv_nmos w=10u l=0.5u ng=1 m=1
Xmt  atail ibias vss vss sg13_lv_nmos w=10u l=0.5u ng=1 m=1
* Input pair. The device whose gate is vinp drives the INVERTING node aon,
* so v(aop) - v(aon) = +A_v * (v(vinp) - v(vinn)).
Xmip aon vinp atail vss sg13_lv_nmos w=20u l=0.5u ng=1 m=1
Xmin aop vinn atail vss sg13_lv_nmos w=20u l=0.5u ng=1 m=1
* Ideal resistor loads. NOT a PDK resistor subckt -- see this file's header
* "THE FRONT-END LOAD IS AN IDEAL RESISTOR" for why.
Rlp vdd aop 20k
Rln vdd aon 20k
.ends comparator_dut_analog

* ---------------------------------------------------------------------------
* comparator_dut_latch -- BEHAVIOURAL regenerative decision stage.
*
* Deliberately behavioural. A transistor-level latch here would be a topology
* choice, and the topology decision is out of scope. What this models is only
* the *observable contract* every latched comparator has, so that the
* regeneration and kickback benches have something real to measure:
*
*   clk low   -> reset: both regeneration nodes pulled to mid-rail
*   clk high  -> evaluate: dv/dt = dv/tau + (input injection), i.e. the
*                exponential regeneration law t = t0 + tau*ln(V/(A*Vin))
*                the regeneration bench extracts tau from
*   output    -> held between decisions, flipping only once the regeneration
*                nodes have separated past an absolute threshold (an SR
*                latch's behaviour, not a differential zero-crossing)
*
* c_fb IS THE PART THAT MATTERS FOR KICKBACK and it is an explicit, declared
* stand-in: a real latch's input pair couples its rail-to-rail regeneration
* nodes back to its inputs through C_gd. Modelling that as an explicit 5 fF
* per side means the kickback bench measures a real path (regeneration node
* -> front-end output -> input-pair C_gd -> input node) instead of reporting
* a fictitious zero. The VALUE is a placeholder like everything else here.
*
* Ported structurally, unchanged in substance, from gf180-comparator's own
* placeholder_comparator.spice: this subckt is PDK-independent (it names no
* device model at all, only ideal behavioural sources referenced to
* v(vdd,vss)), so it needed no adaptation for SG13G2's 1.2 V rail -- every
* threshold below is expressed as a fraction of the supplied vdd/vss, not as
* an absolute volt figure.
* ---------------------------------------------------------------------------
.subckt comparator_dut_latch inp inn clk dout doutb vdd vss
.param g_reg=5m
.param c_reg=500f
.param g_in=5m
.param v_lim=0.4
.param c_fb=5f
.param g_clamp=1
.param r_hold=200
.param c_hold=100f
.param v_th=0.8
.param v_sharp=0.1
.param r_rst=100
* Clock enable, smoothed so the B-source expressions stay differentiable.
Ben  ken 0 v = '0.5*(1+tanh((v(clk)-0.5*v(vdd,vss))/0.05))'
Cqp  qp 0 {c_reg}
Cqn  qn 0 {c_reg}
* Positive feedback (tanh-limited) plus input injection. tau = c_reg/(2*g_reg).
Bqp  0 qp i = 'v(ken)*( g_reg*v_lim*tanh((v(qp)-v(qn))/v_lim) + g_in*(v(inp)-v(inn)) )'
Bqn  0 qn i = '-v(ken)*( g_reg*v_lim*tanh((v(qp)-v(qn))/v_lim) + g_in*(v(inp)-v(inn)) )'
* Reset to mid-rail while clk is low.
Brp  0 qp i = '(1-v(ken))*(0.5*v(vdd,vss)-v(qp))/r_rst'
Brn  0 qn i = '(1-v(ken))*(0.5*v(vdd,vss)-v(qn))/r_rst'
* Rail clamps -- the regeneration nodes are supply-bounded, like real ones.
Bcp  qp 0 i = 'g_clamp*(max(v(qp)-v(vdd),0)+min(v(qp)-v(vss),0))'
Bcn  qn 0 i = 'g_clamp*(max(v(qn)-v(vdd),0)+min(v(qn)-v(vss),0))'
* Latch input pair C_gd, explicit. This is the kickback path (see header).
Ckp  qp inp {c_fb}
Ckn  qn inn {c_fb}
* Output hold. Tracks the decision only once |v(qp)-v(qn)| passes v_th, so
* the output delay is a real function of overdrive rather than of the moment
* the differential crosses zero. Rh keeps the node non-floating for `op`.
Ch   h 0 {c_hold}
Rh   h vss 1G
Bh   0 h i = 'v(ken)*0.5*(1+tanh((abs(v(qp)-v(qn))-v_th)/v_sharp))*(v(vdd,vss)*0.5*(1+tanh((v(qp)-v(qn))/v_sharp))-v(h))/r_hold'
Bdo  dout  0 v = 'min(max(v(h),v(vss)),v(vdd))'
Bdob doutb 0 v = 'v(vdd)-min(max(v(h),v(vss)),v(vdd))'
.ends comparator_dut_latch

* ---------------------------------------------------------------------------
* comparator_dut -- the full clocked comparator the transient benches drive.
* ---------------------------------------------------------------------------
.subckt comparator_dut vinp vinn clk ibias dout doutb vdd vss
Xa vinp vinn ibias aop aon vdd vss comparator_dut_analog
Xl aop aon clk dout doutb vdd vss comparator_dut_latch
.ends comparator_dut

* ---------------- TESTBENCH FRAGMENT ----------------
* tb_preamp_noise -- input-referred noise of the comparator front end,
* measured with ngspice's `.noise` analysis, over the full PVT grid.
*
* Netlist FRAGMENT. The harness supplies the models, the corner .lib
* section, .temp, the DUT netlist, the .control block and .end
* (sim/harness/README.md). Parameters from the harness: vdd_val, vdd_nom,
* temp_c, dut_ib, dut_vcm.
*
* METHODOLOGY PORTED FROM gf180-comparator/sim/comparator-preamp-noise/
* (itself ported from gf180-sar-adc) -- see this experiment's README.md for
* the full transfer/non-transfer list.
*
* THE UNITS CAUTION THAT MADE THIS BENCH WORTH PORTING. ngspice's own
* `inoise_total` is its input referral through the AC transfer function of
* the source you name; the number a comparator noise spec is conventionally
* stated at is the TOTAL INTEGRATED OUTPUT NOISE DIVIDED BY THE MEASURED DC
* GAIN. The sibling repo's own record documents a prior 200x-magnitude
* error from reporting `sqrt(onoise_total)` directly as the answer. So this
* bench reports BOTH -- `vn_in_uv` (onoise_total / A_v, the number that is
* quoted) and `inoise_band_uv` (ngspice's own) -- and the record shows them
* side by side.
*
* WHY THIS BENCH CAN EXIST AT ALL. `.noise` is a small-signal analysis about
* a DC operating point. A reset-and-regenerate decision stage has none, and
* ngspice offers no PSS/pnoise and no automatic device-level transient
* noise. So this bench measures the FRONT END -- which is also where the
* dominant term is, since everything after it is divided by the front-end
* gain. See sim/dut/README.md "Why the DUT is split into three subckts" for
* what happens to this bench if the ratified topology turns out to have no
* DC-resolvable front end at all.
*
* THE DECISION STAGE IS INSTANTIATED HERE, WITH ITS CLOCK HELD LOW. It
* contributes no current in reset, but it presents the input capacitance
* that -- with the front-end load resistance -- sets the noise bandwidth.
* Leaving it out would under-load the node, OVER-state the bandwidth, and so
* OVER-state the noise.
*
* MISMATCH IS OFF (the plain `mos` corner set, not `mos_mismatch`; see
* sim/harness/corners.py). Noise and offset are separate terms budgeted
* separately.

.param c_route=10f

vsup vdd 0 dc {vdd_val}

* ---- ideal standalone stimulus ---------------------------------------
* `vd` is the noise-analysis input source, so ngspice's own inoise_* is
* referred to the DIFFERENTIAL input directly and is comparable with the
* divide-by-gain number this bench actually quotes.
vcm  cm 0 dc {dut_vcm}
vd   vd 0 dc 0 ac 1
Eap  ap cm vd 0 0.5
Ean  an cm vd 0 -0.5

* ---- device under test ------------------------------------------------
ib   vdd ibn dc {dut_ib}
Xa   ap an ibn aop aon vdd 0 comparator_dut_analog

* Decision stage in reset: no current, but its input capacitance is part of
* the load that sets the front end's noise bandwidth.
vclk clk 0 dc 0
Xl   aop aon clk doutl doutbl vdd 0 comparator_dut_latch

* Routing allowance on each front-end output: a stated placeholder for
* interconnect that does not exist until a floorplan does. Kept deliberately
* SMALL, because loading this node harder would lower the noise bandwidth
* and so REDUCE the reported noise -- an optimistic direction. Under-loading
* it is the conservative choice.
Cwp aop 0 {c_route}
Cwn aon 0 {c_route}
