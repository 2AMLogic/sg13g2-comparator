* Netlist snapshot for record 20260916-113303-180cca7 -- exactly what was simulated.
* DUT: comparator-dr0001 (schematic), design/comparator.spice
* Testbench: sim/comparator-preamp-noise/testbench/tb_preamp_noise.spice
* ---------------- DUT NETLIST ----------------
* ============================================================================
* sg13g2-comparator -- DERIVED NETLIST.  DO NOT EDIT BY HAND.
* ============================================================================
*
* Generated from the xschem sources in design/ by:
*
*     python3 design/netlist.py
*
* The schematics are the source of record:
*
*   design/comparator.sch              the design -- a single-tail StrongARM
*                                      dynamic latch (spec/decision-records/
*                                      0001-comparator-topology.md), plus the
*                                      isolation inverters and NOR SR latch
*                                      that make its outputs HELD between
*                                      strobes as the interface contract
*                                      requires
*   design/comparator_dut.sch          contract wrapper: tail-bias reference
*                                      on the `ibias` pin + the core
*   design/comparator_dut_latch.sch    contract wrapper: the core with its
*                                      tail-bias node tied to vdd
*   design/comparator_dut_analog.sch   the LOOP-BROKEN reduced sub-model --
*                                      an offset/noise LOWER BOUND, not the
*                                      design's front end.  Read
*                                      design/README.md before quoting any
*                                      number measured against it.
*
* Interface contract: sim/dut/README.md.  Asserted at generation time by
* design/netlist.py (against sim/harness/dut.py's own REQUIRED_SUBCKTS) and
* again at load time by the harness.
*
* Parameters supplied by the harness, not by this file: dut_ib, dut_vcm,
* vdd_val, vdd_nom, temp_c (sim/harness/runner.py compose_deck).  This file
* deliberately contains no .include / .lib / .temp / .control / .endc / .end.
* ============================================================================

.subckt comparator vinp vinn clk vbias dout doutb vdd vss
*.iopin vinp
*.iopin vinn
*.iopin clk
*.iopin vbias
*.iopin dout
*.iopin doutb
*.iopin vdd
*.iopin vss
XMT tmid vbias vss vss sg13_lv_nmos w=40u l=0.5u ng=1 m=1
XMSW tail clk tmid vss sg13_lv_nmos w=40u l=0.13u ng=1 m=1
XM1 np vinp tail vss sg13_lv_nmos w=12u l=0.34u ng=1 m=1
XM2 nn vinn tail vss sg13_lv_nmos w=12u l=0.34u ng=1 m=1
XM3 ln lp np vss sg13_lv_nmos w=3u l=0.13u ng=1 m=1
XM4 lp ln nn vss sg13_lv_nmos w=3u l=0.13u ng=1 m=1
XM5 ln lp vdd vdd sg13_lv_pmos w=3u l=0.13u ng=1 m=1
XM6 lp ln vdd vdd sg13_lv_pmos w=3u l=0.13u ng=1 m=1
XM7 ln clk vdd vdd sg13_lv_pmos w=6u l=0.13u ng=1 m=1
XM8 lp clk vdd vdd sg13_lv_pmos w=6u l=0.13u ng=1 m=1
XM9 np clk vdd vdd sg13_lv_pmos w=3u l=0.13u ng=1 m=1
XM10 nn clk vdd vdd sg13_lv_pmos w=3u l=0.13u ng=1 m=1
XMIAP lnb ln vdd vdd sg13_lv_pmos w=3u l=0.13u ng=1 m=1
XMIAN lnb ln vss vss sg13_lv_nmos w=1.5u l=0.13u ng=1 m=1
XMIBP lpb lp vdd vdd sg13_lv_pmos w=3u l=0.13u ng=1 m=1
XMIBN lpb lp vss vss sg13_lv_nmos w=1.5u l=0.13u ng=1 m=1
XMNAP1 na lnb vdd vdd sg13_lv_pmos w=4u l=0.13u ng=1 m=1
XMNAP2 doutb dout na vdd sg13_lv_pmos w=4u l=0.13u ng=1 m=1
XMNAN1 doutb lnb vss vss sg13_lv_nmos w=1.5u l=0.13u ng=1 m=1
XMNAN2 doutb dout vss vss sg13_lv_nmos w=1.5u l=0.13u ng=1 m=1
XMNBP1 nb lpb vdd vdd sg13_lv_pmos w=4u l=0.13u ng=1 m=1
XMNBP2 dout doutb nb vdd sg13_lv_pmos w=4u l=0.13u ng=1 m=1
XMNBN1 dout lpb vss vss sg13_lv_nmos w=1.5u l=0.13u ng=1 m=1
XMNBN2 dout doutb vss vss sg13_lv_nmos w=1.5u l=0.13u ng=1 m=1
.ends

.subckt comparator_dut_analog vinp vinn ibias aop aon vdd vss
*.iopin vinp
*.iopin vinn
*.iopin ibias
*.iopin aop
*.iopin aon
*.iopin vdd
*.iopin vss
XMBA ibias ibias vss vss sg13_lv_nmos w=10u l=0.5u ng=1 m=1
XMTA tmid ibias vss vss sg13_lv_nmos w=40u l=0.5u ng=1 m=1
XMSWA tail vdd tmid vss sg13_lv_nmos w=40u l=0.13u ng=1 m=1
XM1A aon vinp tail vss sg13_lv_nmos w=12u l=0.34u ng=1 m=1
XM2A aop vinn tail vss sg13_lv_nmos w=12u l=0.34u ng=1 m=1
XM5A aon aon vdd vdd sg13_lv_pmos w=3u l=0.13u ng=1 m=1
XM6A aop aop vdd vdd sg13_lv_pmos w=3u l=0.13u ng=1 m=1
.ends

.subckt comparator_dut_latch inp inn clk dout doutb vdd vss
*.iopin inp
*.iopin inn
*.iopin clk
*.iopin dout
*.iopin doutb
*.iopin vdd
*.iopin vss
x1 inp inn clk vdd dout doutb vdd vss comparator
.ends

.subckt comparator_dut vinp vinn clk ibias dout doutb vdd vss
*.iopin vinp
*.iopin vinn
*.iopin clk
*.iopin ibias
*.iopin dout
*.iopin doutb
*.iopin vdd
*.iopin vss
XMB ibias ibias vss vss sg13_lv_nmos w=10u l=0.5u ng=1 m=1
x1 vinp vinn clk ibias dout doutb vdd vss comparator
.ends

* ---------------- TESTBENCH FRAGMENT ----------------
* tb_preamp_noise -- input-referred noise of the comparator front end,
* measured with ngspice's `.noise` analysis, over the full PVT grid.
*
* Netlist FRAGMENT. The harness supplies the models, the corner .lib
* section, .temp, the DUT netlist, the .control block and .end
* (sim/harness/README.md). Parameters from the harness: vdd_val, vdd_nom,
* temp_c, dut_ib, dut_vcm.
*
* METHODOLOGY PORTED FROM gf180-comparator/sim/comparator-preamp-noise/
* (itself ported from gf180-sar-adc) -- see this experiment's README.md for
* the full transfer/non-transfer list.
*
* THE UNITS CAUTION THAT MADE THIS BENCH WORTH PORTING. ngspice's own
* `inoise_total` is its input referral through the AC transfer function of
* the source you name; the number a comparator noise spec is conventionally
* stated at is the TOTAL INTEGRATED OUTPUT NOISE DIVIDED BY THE MEASURED DC
* GAIN. The sibling repo's own record documents a prior 200x-magnitude
* error from reporting `sqrt(onoise_total)` directly as the answer. So this
* bench reports BOTH -- `vn_in_uv` (onoise_total / A_v, the number that is
* quoted) and `inoise_band_uv` (ngspice's own) -- and the record shows them
* side by side.
*
* WHY THIS BENCH CAN EXIST AT ALL. `.noise` is a small-signal analysis about
* a DC operating point. A reset-and-regenerate decision stage has none, and
* ngspice offers no PSS/pnoise and no automatic device-level transient
* noise. So this bench measures the FRONT END -- which is also where the
* dominant term is, since everything after it is divided by the front-end
* gain. See sim/dut/README.md "Why the DUT is split into three subckts" for
* what happens to this bench if the ratified topology turns out to have no
* DC-resolvable front end at all.
*
* THE DECISION STAGE IS INSTANTIATED HERE, WITH ITS CLOCK HELD LOW. It
* contributes no current in reset, but it presents the input capacitance
* that -- with the front-end load resistance -- sets the noise bandwidth.
* Leaving it out would under-load the node, OVER-state the bandwidth, and so
* OVER-state the noise.
*
* MISMATCH IS OFF (the plain `mos` corner set, not `mos_mismatch`; see
* sim/harness/corners.py). Noise and offset are separate terms budgeted
* separately.

.param c_route=10f

vsup vdd 0 dc {vdd_val}

* ---- ideal standalone stimulus ---------------------------------------
* `vd` is the noise-analysis input source, so ngspice's own inoise_* is
* referred to the DIFFERENTIAL input directly and is comparable with the
* divide-by-gain number this bench actually quotes.
vcm  cm 0 dc {dut_vcm}
vd   vd 0 dc 0 ac 1
Eap  ap cm vd 0 0.5
Ean  an cm vd 0 -0.5

* ---- device under test ------------------------------------------------
ib   vdd ibn dc {dut_ib}
Xa   ap an ibn aop aon vdd 0 comparator_dut_analog

* Decision stage in reset: no current, but its input capacitance is part of
* the load that sets the front end's noise bandwidth.
vclk clk 0 dc 0
Xl   aop aon clk doutl doutbl vdd 0 comparator_dut_latch

* Routing allowance on each front-end output: a stated placeholder for
* interconnect that does not exist until a floorplan does. Kept deliberately
* SMALL, because loading this node harder would lower the noise bandwidth
* and so REDUCE the reported noise -- an optimistic direction. Under-loading
* it is the conservative choice.
Cwp aop 0 {c_route}
Cwn aon 0 {c_route}
