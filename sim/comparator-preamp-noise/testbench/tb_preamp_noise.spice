* tb_preamp_noise -- input-referred noise of the comparator front end,
* measured with ngspice's `.noise` analysis, over the full PVT grid.
*
* Netlist FRAGMENT. The harness supplies the models, the corner .lib
* section, .temp, the DUT netlist, the .control block and .end
* (sim/harness/README.md). Parameters from the harness: vdd_val, vdd_nom,
* temp_c, dut_ib, dut_vcm.
*
* METHODOLOGY PORTED FROM gf180-comparator/sim/comparator-preamp-noise/
* (itself ported from gf180-sar-adc) -- see this experiment's README.md for
* the full transfer/non-transfer list.
*
* THE UNITS CAUTION THAT MADE THIS BENCH WORTH PORTING. ngspice's own
* `inoise_total` is its input referral through the AC transfer function of
* the source you name; the number a comparator noise spec is conventionally
* stated at is the TOTAL INTEGRATED OUTPUT NOISE DIVIDED BY THE MEASURED DC
* GAIN. The sibling repo's own record documents a prior 200x-magnitude
* error from reporting `sqrt(onoise_total)` directly as the answer. So this
* bench reports BOTH -- `vn_in_uv` (onoise_total / A_v, the number that is
* quoted) and `inoise_band_uv` (ngspice's own) -- and the record shows them
* side by side.
*
* WHY THIS BENCH CAN EXIST AT ALL. `.noise` is a small-signal analysis about
* a DC operating point. A reset-and-regenerate decision stage has none, and
* ngspice offers no PSS/pnoise and no automatic device-level transient
* noise. So this bench measures the FRONT END -- which is also where the
* dominant term is, since everything after it is divided by the front-end
* gain. See sim/dut/README.md "Why the DUT is split into three subckts" for
* what happens to this bench if the ratified topology turns out to have no
* DC-resolvable front end at all.
*
* THE DECISION STAGE IS INSTANTIATED HERE, WITH ITS CLOCK HELD LOW. It
* contributes no current in reset, but it presents the input capacitance
* that -- with the front-end load resistance -- sets the noise bandwidth.
* Leaving it out would under-load the node, OVER-state the bandwidth, and so
* OVER-state the noise.
*
* MISMATCH IS OFF (the plain `mos` corner set, not `mos_mismatch`; see
* sim/harness/corners.py). Noise and offset are separate terms budgeted
* separately.

.param c_route=10f

vsup vdd 0 dc {vdd_val}

* ---- ideal standalone stimulus ---------------------------------------
* `vd` is the noise-analysis input source, so ngspice's own inoise_* is
* referred to the DIFFERENTIAL input directly and is comparable with the
* divide-by-gain number this bench actually quotes.
vcm  cm 0 dc {dut_vcm}
vd   vd 0 dc 0 ac 1
Eap  ap cm vd 0 0.5
Ean  an cm vd 0 -0.5

* ---- device under test ------------------------------------------------
ib   vdd ibn dc {dut_ib}
Xa   ap an ibn aop aon vdd 0 comparator_dut_analog

* Decision stage in reset: no current, but its input capacitance is part of
* the load that sets the front end's noise bandwidth.
vclk clk 0 dc 0
Xl   aop aon clk doutl doutbl vdd 0 comparator_dut_latch

* Routing allowance on each front-end output: a stated placeholder for
* interconnect that does not exist until a floorplan does. Kept deliberately
* SMALL, because loading this node harder would lower the noise bandwidth
* and so REDUCE the reported noise -- an optimistic direction. Under-loading
* it is the conservative choice.
Cwp aop 0 {c_route}
Cwn aon 0 {c_route}
