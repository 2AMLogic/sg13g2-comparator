* klt sim -- generated corner deck, do not edit
.options seed=505240162
.param mc_sample_index=11
.param mc_process_seed=168970495
.param mc_mismatch_seed=1998433463
.lib /opt/pdk/ihp-sg13g2/libs.tech/ngspice/models/cornerMOSlv.lib mos_fs_mismatch
.include /var/tmp/eda-job-klt-sim-681b9123fdb7/inputs/netlist.cir
.temp -40
.meas tran vdd_meas find v(vdd) at=5n
.meas tran temp_meas find v(tcheck) at=1n
.meas tran vbias_mv find par('v(ibn)*1e3') at=5n
.meas tran lowcount param='33-(dlev0+dlev1+dlev2+dlev3+dlev4+dlev5+dlev6+dlev7+dlev8+dlev9+dlev10+dlev11+dlev12+dlev13+dlev14+dlev15+dlev16+dlev17+dlev18+dlev19+dlev20+dlev21+dlev22+dlev23+dlev24+dlev25+dlev26+dlev27+dlev28+dlev29+dlev30+dlev31+dlev32)'
.meas tran vos_mv param='(-0.048+(lowcount-0.5)*0.003)*1e3'
.control
alter vsup=1.2
tran 100p 990n
quit
.endc
.end
