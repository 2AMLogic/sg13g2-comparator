* regeneration -- klt sim netlist BODY (sim/klt-corner-verification, issue #62)
* GENERATED by `python3 sim/run_klt_corner_verification.py build` -- do not edit;
* edit the inputs below and rebuild.
*   circuit: sim/klt-corner-verification/benches/regeneration.circuit.spice  sha256=dbe18394f920b52aa36b6b4275f2b2ecf94f9701b3294299ff04c583a625ab39
*   DUT:     design/comparator.spice  sha256=186f21b0c5998e31dc8febb366aa434e305f1d6fd7f174acf0bc05aaa23df89c
*            sim/dut.json id=comparator-dr0001 provenance=schematic
*   OSDI:    /opt/pdk/ihp-sg13g2/libs.tech/ngspice/osdi
*   OVERRIDE (issue #80 sweep; sim/dut.json untouched): dut_ib=1e-05
*   CANDIDATE NETLIST (issue #497 integration-capacitance study; design/comparator.spice untouched): name=cadd4f path=sim/comparator-integration-capacitance/candidates/cadd4f.spice sha256=f8a53301035e36cc060fd09985a79aaeb539088666b3855bd8aef63baac1f9e3
*   GEOMETRY OVERRIDE (issue #92 sizing study; design/comparator.spice untouched): XM1.w=8u XM2.w=8u XM3.w=6u XM4.w=6u XM5.w=6u XM6.w=6u XMSW.w=20u
*   base candidate cadd4f (unmodified) sha256=f8a53301035e36cc060fd09985a79aaeb539088666b3855bd8aef63baac1f9e3
*
* klt sim netlist-body convention: no .lib / .temp / analysis / .end here --
* klt sim generates those per corner around an .include of this file. The
* .control block below is the one deliberate deviation (see
* sim/kltsim/build.py): SG13G2's MOS models are OSDI and must be
* pre_osdi-loaded before the circuit is parsed, and the pinned klt has no
* request field for that.
.control
pre_osdi /opt/pdk/ihp-sg13g2/libs.tech/ngspice/osdi/psp103.osdi
pre_osdi /opt/pdk/ihp-sg13g2/libs.tech/ngspice/osdi/psp103_nqs.osdi
pre_osdi /opt/pdk/ihp-sg13g2/libs.tech/ngspice/osdi/r3_cmc.osdi
pre_osdi /opt/pdk/ihp-sg13g2/libs.tech/ngspice/osdi/mosvar.osdi
.endc

* ---- DUT operating point (sim/dut.json params) ----
.param dut_ib=1e-05
.param dut_vcm=0.6

* ==== BEGIN DUT sim/comparator-integration-capacitance/candidates/cadd4f.spice sha256=186f21b0c5998e31dc8febb366aa434e305f1d6fd7f174acf0bc05aaa23df89c ====
* ============================================================================
* sg13g2-comparator -- DERIVED NETLIST.  DO NOT EDIT BY HAND.
* ============================================================================
*
* Generated from the xschem sources in design/ by:
*
*     python3 design/netlist.py
*
* The schematics are the source of record:
*
*   design/comparator.sch              the design -- a single-tail StrongARM
*                                      dynamic latch (spec/decision-records/
*                                      0001-comparator-topology.md), plus the
*                                      isolation inverters and NOR SR latch
*                                      that make its outputs HELD between
*                                      strobes as the interface contract
*                                      requires
*   design/comparator_dut.sch          contract wrapper: tail-bias reference
*                                      on the `ibias` pin + the core
*   design/comparator_dut_latch.sch    contract wrapper: the core with its
*                                      tail-bias node tied to vdd
*   design/comparator_dut_analog.sch   the LOOP-BROKEN reduced sub-model --
*                                      an offset/noise LOWER BOUND, not the
*                                      design's front end.  Read
*                                      design/README.md before quoting any
*                                      number measured against it.
*
* Interface contract: sim/dut/README.md.  Asserted at generation time by
* design/netlist.py (against sim/harness/dut.py's own REQUIRED_SUBCKTS) and
* again at load time by the harness.
*
* Parameters supplied by the harness, not by this file: dut_ib, dut_vcm,
* vdd_val, vdd_nom, temp_c (sim/harness/runner.py compose_deck).  This file
* deliberately contains no .include / .lib / .temp / .control / .endc / .end.
* ============================================================================

.subckt comparator vinp vinn clk vbias dout doutb vdd vss
*.iopin vinp
*.iopin vinn
*.iopin clk
*.iopin vbias
*.iopin dout
*.iopin doutb
*.iopin vdd
*.iopin vss
XMT tmid vbias vss vss sg13_lv_nmos w=40u l=0.5u ng=1 m=1
XMSW tail clk tmid vss sg13_lv_nmos w=20u l=0.13u ng=1 m=1
XM1 np vinp tail vss sg13_lv_nmos w=8u l=0.34u ng=1 m=1
XM2 nn vinn tail vss sg13_lv_nmos w=8u l=0.34u ng=1 m=1
XM3 ln lp np vss sg13_lv_nmos w=6u l=0.13u ng=1 m=1
XM4 lp ln nn vss sg13_lv_nmos w=6u l=0.13u ng=1 m=1
XM5 ln lp vdd vdd sg13_lv_pmos w=6u l=0.13u ng=1 m=1
XM6 lp ln vdd vdd sg13_lv_pmos w=6u l=0.13u ng=1 m=1
XM7 ln clk vdd vdd sg13_lv_pmos w=6u l=0.13u ng=1 m=1
XM8 lp clk vdd vdd sg13_lv_pmos w=6u l=0.13u ng=1 m=1
XM9 np clk vdd vdd sg13_lv_pmos w=3u l=0.13u ng=1 m=1
XM10 nn clk vdd vdd sg13_lv_pmos w=3u l=0.13u ng=1 m=1
XMIAP lnb ln vdd vdd sg13_lv_pmos w=3u l=0.13u ng=1 m=1
XMIAN lnb ln vss vss sg13_lv_nmos w=1.5u l=0.13u ng=1 m=1
XMIBP lpb lp vdd vdd sg13_lv_pmos w=3u l=0.13u ng=1 m=1
XMIBN lpb lp vss vss sg13_lv_nmos w=1.5u l=0.13u ng=1 m=1
XMNAP1 na lnb vdd vdd sg13_lv_pmos w=4u l=0.13u ng=1 m=1
XMNAP2 doutb dout na vdd sg13_lv_pmos w=4u l=0.13u ng=1 m=1
XMNAN1 doutb lnb vss vss sg13_lv_nmos w=1.5u l=0.13u ng=1 m=1
XMNAN2 doutb dout vss vss sg13_lv_nmos w=1.5u l=0.13u ng=1 m=1
XMNBP1 nb lpb vdd vdd sg13_lv_pmos w=4u l=0.13u ng=1 m=1
XMNBP2 dout doutb nb vdd sg13_lv_pmos w=4u l=0.13u ng=1 m=1
XMNBN1 dout lpb vss vss sg13_lv_nmos w=1.5u l=0.13u ng=1 m=1
XMNBN2 dout doutb vss vss sg13_lv_nmos w=1.5u l=0.13u ng=1 m=1
* issue #497: matched integration-node capacitance, per side, node to the vss rail
C497P np vss 4f
C497N nn vss 4f
.ends

.subckt comparator_dut_analog vinp vinn ibias aop aon vdd vss
*.iopin vinp
*.iopin vinn
*.iopin ibias
*.iopin aop
*.iopin aon
*.iopin vdd
*.iopin vss
XMBA ibias ibias vss vss sg13_lv_nmos w=10u l=0.5u ng=1 m=1
XMTA tmid ibias vss vss sg13_lv_nmos w=40u l=0.5u ng=1 m=1
XMSWA tail vdd tmid vss sg13_lv_nmos w=40u l=0.13u ng=1 m=1
XM1A aon vinp tail vss sg13_lv_nmos w=12u l=0.34u ng=1 m=1
XM2A aop vinn tail vss sg13_lv_nmos w=12u l=0.34u ng=1 m=1
XM5A aon aon vdd vdd sg13_lv_pmos w=3u l=0.13u ng=1 m=1
XM6A aop aop vdd vdd sg13_lv_pmos w=3u l=0.13u ng=1 m=1
* issue #497: the same per-side capacitance at the loop-broken model's integration
* nodes (np maps to aon, nn maps to aop)
C497AP aon vss 4f
C497AN aop vss 4f
.ends

.subckt comparator_dut_latch inp inn clk dout doutb vdd vss
*.iopin inp
*.iopin inn
*.iopin clk
*.iopin dout
*.iopin doutb
*.iopin vdd
*.iopin vss
x1 inp inn clk vdd dout doutb vdd vss comparator
.ends

.subckt comparator_dut vinp vinn clk ibias dout doutb vdd vss
*.iopin vinp
*.iopin vinn
*.iopin clk
*.iopin ibias
*.iopin dout
*.iopin doutb
*.iopin vdd
*.iopin vss
XMB ibias ibias vss vss sg13_lv_nmos w=10u l=0.5u ng=1 m=1
x1 vinp vinn clk ibias dout doutb vdd vss comparator
.ends
* ==== END DUT ====

* ---- bench: regeneration (klt sim port of sim/comparator-regeneration) --
*
* Circuit is sim/comparator-regeneration/testbench/tb_regeneration.spice's,
* carried over element for element, with ONE structural change forced by
* klt sim's supply axis: klt sim sweeps supply by `alter vsup=<V>` /
* `alter vsupa=<V>` in its generated .control block, which changes those
* two sources' DC values and nothing else. The original deck's clock was
* `pulse(0 {vdd_val} ...)`, i.e. its amplitude was the .param, which `alter`
* does not reach. Here the clock is a unit pulse scaled by the live supply
* node (Bclk), so the strobe swings rail to rail at every supply corner,
* exactly as the harness deck's {vdd_val} clock did. Everything else
* (overdrive ladder, PWL input flip at t_flip, per-instance bias sources,
* supply-normalized probes, solver options) is unchanged.
*
* Supply sources: vsup (instances B, C, the clock reference) and vsupa
* (instance A alone, so its supply current -- core plus its own tail-bias
* reference branch iba -- can be integrated for the power row). The
* request sweeps both keys together by index.

.options reltol=1e-4 vntol=1e-9 abstol=1e-13

.param dv_big=50m
.param dv_mid=1m
.param dv_tiny=0.1m
.param t_flip=20n
.param c_route=10f

* ---- supplies (DC value is a placeholder; klt sim alters it per corner) --
vsup  vdd  0 dc 1.2
vsupa vdda 0 dc 1.2

* ---- clock: two strobes, decision measured on the second --------------
* unit pulse identical in timing to the original `pulse(0 {vdd_val} 10n
* 100p 100p 10n 30n)`, scaled by the altered supply.
vclku clku 0 pulse(0 1 10n 100p 100p 10n 30n)
Bclk  clk  0 v = 'v(clku)*v(vdd)'

* ---- common mode ------------------------------------------------------
vcm cm 0 dc {dut_vcm}

* ---- A: 50 mV overdrive, on its own supply ----------------------------
vsa  sa 0 pwl(0 {-dv_big} {t_flip} {-dv_big} {t_flip+1n} {dv_big})
Eapa apa cm sa 0 0.5
Eana ana cm sa 0 -0.5
iba  vdda ibna dc {dut_ib}
Xa   apa ana clk ibna douta doutba vdda 0 comparator_dut

* ---- B: 1 mV overdrive --------------------------------------------------
vsb  sb 0 pwl(0 {-dv_mid} {t_flip} {-dv_mid} {t_flip+1n} {dv_mid})
Eapb apb cm sb 0 0.5
Eanb anb cm sb 0 -0.5
ibb  vdd ibnb dc {dut_ib}
Xb   apb anb clk ibnb doutb doutbb vdd 0 comparator_dut

* ---- C: 0.1 mV overdrive (tau lever arm / metastability probe) ----------
vsc  sc 0 pwl(0 {-dv_tiny} {t_flip} {-dv_tiny} {t_flip+1n} {dv_tiny})
Eapc apc cm sc 0 0.5
Eanc anc cm sc 0 -0.5
ibc  vdd ibnc dc {dut_ib}
Xc   apc anc clk ibnc doutc doutbc vdd 0 comparator_dut

* ---- supply-normalized probes ------------------------------------------
Bclkn clkn 0 v = 'v(clk)/v(vdd)'
Bdan  dan  0 v = 'v(douta)/v(vdda)'
Bdbn  dbn  0 v = 'v(doutb)/v(vdd)'
Bdcn  dcn  0 v = 'v(doutc)/v(vdd)'

* ---- corner-application probes (not in the original deck) --------------
* These exist so the grading adapter can prove, per corner, that klt sim's
* supply `alter` and `.temp` card actually reached the circuit: tcheck reads
* ngspice's own simulation temperature, and the request measures v(vdd)/
* v(vdda) directly.
Btchk tcheck 0 v = 'temper'
