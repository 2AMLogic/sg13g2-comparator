* transient_noise -- klt sim netlist BODY (sim/klt-corner-verification, issue #62)
* GENERATED by `python3 sim/run_klt_corner_verification.py build` -- do not edit;
* edit the inputs below and rebuild.
*   circuit: sim/klt-corner-verification/benches/transient_noise.circuit.spice  sha256=854111f94e98ebcfd715388c3ad890b717cf111641a604b2e8a96e91db724d21
*   DUT:     design/comparator.spice  sha256=186f21b0c5998e31dc8febb366aa434e305f1d6fd7f174acf0bc05aaa23df89c
*            sim/dut.json id=comparator-dr0001 provenance=schematic
*   OSDI:    /opt/pdk/ihp-sg13g2/libs.tech/ngspice/osdi
*   OVERRIDE (issue #80 sweep; sim/dut.json untouched): dut_ib=1e-05
*   CANDIDATE NETLIST (issue #497 integration-capacitance study; design/comparator.spice untouched): name=cadd4f path=sim/comparator-integration-capacitance/candidates/cadd4f.spice sha256=f8a53301035e36cc060fd09985a79aaeb539088666b3855bd8aef63baac1f9e3
*   GEOMETRY OVERRIDE (issue #92 sizing study; design/comparator.spice untouched): XM1.w=8u XM2.w=8u XM3.w=6u XM4.w=6u XM5.w=6u XM6.w=6u XMSW.w=20u
*   base candidate cadd4f (unmodified) sha256=f8a53301035e36cc060fd09985a79aaeb539088666b3855bd8aef63baac1f9e3
*
* klt sim netlist-body convention: no .lib / .temp / analysis / .end here --
* klt sim generates those per corner around an .include of this file. The
* .control block below is the one deliberate deviation (see
* sim/kltsim/build.py): SG13G2's MOS models are OSDI and must be
* pre_osdi-loaded before the circuit is parsed, and the pinned klt has no
* request field for that.
.control
pre_osdi /opt/pdk/ihp-sg13g2/libs.tech/ngspice/osdi/psp103.osdi
pre_osdi /opt/pdk/ihp-sg13g2/libs.tech/ngspice/osdi/psp103_nqs.osdi
pre_osdi /opt/pdk/ihp-sg13g2/libs.tech/ngspice/osdi/r3_cmc.osdi
pre_osdi /opt/pdk/ihp-sg13g2/libs.tech/ngspice/osdi/mosvar.osdi
.endc

* ---- DUT operating point (sim/dut.json params) ----
.param dut_ib=1e-05
.param dut_vcm=0.6

* ==== BEGIN DUT sim/comparator-integration-capacitance/candidates/cadd4f.spice sha256=186f21b0c5998e31dc8febb366aa434e305f1d6fd7f174acf0bc05aaa23df89c ====
* ============================================================================
* sg13g2-comparator -- DERIVED NETLIST.  DO NOT EDIT BY HAND.
* ============================================================================
*
* Generated from the xschem sources in design/ by:
*
*     python3 design/netlist.py
*
* The schematics are the source of record:
*
*   design/comparator.sch              the design -- a single-tail StrongARM
*                                      dynamic latch (spec/decision-records/
*                                      0001-comparator-topology.md), plus the
*                                      isolation inverters and NOR SR latch
*                                      that make its outputs HELD between
*                                      strobes as the interface contract
*                                      requires
*   design/comparator_dut.sch          contract wrapper: tail-bias reference
*                                      on the `ibias` pin + the core
*   design/comparator_dut_latch.sch    contract wrapper: the core with its
*                                      tail-bias node tied to vdd
*   design/comparator_dut_analog.sch   the LOOP-BROKEN reduced sub-model --
*                                      an offset/noise LOWER BOUND, not the
*                                      design's front end.  Read
*                                      design/README.md before quoting any
*                                      number measured against it.
*
* Interface contract: sim/dut/README.md.  Asserted at generation time by
* design/netlist.py (against sim/harness/dut.py's own REQUIRED_SUBCKTS) and
* again at load time by the harness.
*
* Parameters supplied by the harness, not by this file: dut_ib, dut_vcm,
* vdd_val, vdd_nom, temp_c (sim/harness/runner.py compose_deck).  This file
* deliberately contains no .include / .lib / .temp / .control / .endc / .end.
* ============================================================================

.subckt comparator vinp vinn clk vbias dout doutb vdd vss
*.iopin vinp
*.iopin vinn
*.iopin clk
*.iopin vbias
*.iopin dout
*.iopin doutb
*.iopin vdd
*.iopin vss
XMT tmid vbias vss vss sg13_lv_nmos w=40u l=0.5u ng=1 m=1
XMSW tail clk tmid vss sg13_lv_nmos w=20u l=0.13u ng=1 m=1
XM1 np vinp tail vss sg13_lv_nmos w=8u l=0.34u ng=1 m=1
XM2 nn vinn tail vss sg13_lv_nmos w=8u l=0.34u ng=1 m=1
XM3 ln lp np vss sg13_lv_nmos w=6u l=0.13u ng=1 m=1
XM4 lp ln nn vss sg13_lv_nmos w=6u l=0.13u ng=1 m=1
XM5 ln lp vdd vdd sg13_lv_pmos w=6u l=0.13u ng=1 m=1
XM6 lp ln vdd vdd sg13_lv_pmos w=6u l=0.13u ng=1 m=1
XM7 ln clk vdd vdd sg13_lv_pmos w=6u l=0.13u ng=1 m=1
XM8 lp clk vdd vdd sg13_lv_pmos w=6u l=0.13u ng=1 m=1
XM9 np clk vdd vdd sg13_lv_pmos w=3u l=0.13u ng=1 m=1
XM10 nn clk vdd vdd sg13_lv_pmos w=3u l=0.13u ng=1 m=1
XMIAP lnb ln vdd vdd sg13_lv_pmos w=3u l=0.13u ng=1 m=1
XMIAN lnb ln vss vss sg13_lv_nmos w=1.5u l=0.13u ng=1 m=1
XMIBP lpb lp vdd vdd sg13_lv_pmos w=3u l=0.13u ng=1 m=1
XMIBN lpb lp vss vss sg13_lv_nmos w=1.5u l=0.13u ng=1 m=1
XMNAP1 na lnb vdd vdd sg13_lv_pmos w=4u l=0.13u ng=1 m=1
XMNAP2 doutb dout na vdd sg13_lv_pmos w=4u l=0.13u ng=1 m=1
XMNAN1 doutb lnb vss vss sg13_lv_nmos w=1.5u l=0.13u ng=1 m=1
XMNAN2 doutb dout vss vss sg13_lv_nmos w=1.5u l=0.13u ng=1 m=1
XMNBP1 nb lpb vdd vdd sg13_lv_pmos w=4u l=0.13u ng=1 m=1
XMNBP2 dout doutb nb vdd sg13_lv_pmos w=4u l=0.13u ng=1 m=1
XMNBN1 dout lpb vss vss sg13_lv_nmos w=1.5u l=0.13u ng=1 m=1
XMNBN2 dout doutb vss vss sg13_lv_nmos w=1.5u l=0.13u ng=1 m=1
* issue #497: matched integration-node capacitance, per side, node to the vss rail
C497P np vss 4f
C497N nn vss 4f
.ends

.subckt comparator_dut_analog vinp vinn ibias aop aon vdd vss
*.iopin vinp
*.iopin vinn
*.iopin ibias
*.iopin aop
*.iopin aon
*.iopin vdd
*.iopin vss
XMBA ibias ibias vss vss sg13_lv_nmos w=10u l=0.5u ng=1 m=1
XMTA tmid ibias vss vss sg13_lv_nmos w=40u l=0.5u ng=1 m=1
XMSWA tail vdd tmid vss sg13_lv_nmos w=40u l=0.13u ng=1 m=1
XM1A aon vinp tail vss sg13_lv_nmos w=12u l=0.34u ng=1 m=1
XM2A aop vinn tail vss sg13_lv_nmos w=12u l=0.34u ng=1 m=1
XM5A aon aon vdd vdd sg13_lv_pmos w=3u l=0.13u ng=1 m=1
XM6A aop aop vdd vdd sg13_lv_pmos w=3u l=0.13u ng=1 m=1
* issue #497: the same per-side capacitance at the loop-broken model's integration
* nodes (np maps to aon, nn maps to aop)
C497AP aon vss 4f
C497AN aop vss 4f
.ends

.subckt comparator_dut_latch inp inn clk dout doutb vdd vss
*.iopin inp
*.iopin inn
*.iopin clk
*.iopin dout
*.iopin doutb
*.iopin vdd
*.iopin vss
x1 inp inn clk vdd dout doutb vdd vss comparator
.ends

.subckt comparator_dut vinp vinn clk ibias dout doutb vdd vss
*.iopin vinp
*.iopin vinn
*.iopin clk
*.iopin ibias
*.iopin dout
*.iopin doutb
*.iopin vdd
*.iopin vss
XMB ibias ibias vss vss sg13_lv_nmos w=10u l=0.5u ng=1 m=1
x1 vinp vinn clk ibias dout doutb vdd vss comparator
.ends
* ==== END DUT ====

* ---- bench: transient_noise (klt sim port of sim/comparator-transient-noise)
*
* Circuit is sim/comparator-transient-noise/testbench/tb_transient_noise.spice's,
* carried over element for element: three whole-latch comparator_dut
* instances at -od_x / 0 / +od_x differential overdrive, each driven through
* its OWN trnoise() source at the calibrated density (vn_na = 5.735e-3 at
* vn_ts = 20 ps <=> 36.27 nV/sqrt(Hz), white only, the original tb.json's
* params copied verbatim), one strobe, the decision read INSIDE the evaluate
* phase at 5 ns (CLK falls at 5.1 ns), mismatch off (plain mos_<p> sections).
* Solver options are the original tb.json's (reltol=1e-2 abstol=1e-12).
*
* What changes, and why:
*
* 1. ONE TRIAL PER klt sim MONTE-CARLO SAMPLE, not a `dowhile ... reset`
*    loop. klt sim owns the .control block (one analysis per corner unit,
*    klayout-tools#2482), so the original's in-process loop of N = 80 trials
*    cannot be expressed. Instead the request asks for monte_carlo n = 80:
*    80 separate ngspice runs per PVT point, each one trial. The per-corner
*    MEAN of a 0/1 decision probe over those 80 samples is exactly the
*    original's frac_high_* (fraction of trials deciding HIGH).
*
* 2. SUPPLY-TRACKING CLOCK (same change as the other klt benches): klt sim
*    sweeps supply with `alter vsup=<V>`, which does not reach a .param'd
*    pulse amplitude, so the strobe is a unit pulse scaled by v(vdd).
*
* 3. BINARIZED DECISION PROBES h0/h1/h2 = u(dout/vdd - 0.5), so each sample
*    contributes exactly 0 or 1 and klt's per-corner mean is a fraction, not
*    an average of partially-resolved voltages. Resolution gates (|dout/vdd
*    - 0.5| >= 0.4 at 5 ns) reject a sample whose output had not resolved.
*
* 4. A RAW-NOISE INDEPENDENCE PROBE. ngspice-46's TRNOISE generator is not
*    controlled by setseed / set rndseed / .options seed
*    (sim/comparator-transient-noise/README.md, "Seed reproducibility"), so
*    klt's per-sample `.options seed=` does NOT make these draws
*    reproducible, and whether 80 separately launched runs draw INDEPENDENT
*    noise is an empirical property of the engine, not of klt's seed
*    contract. The request therefore measures the injected source value
*    itself at three instants; kltsim.grade refuses a PVT point if any two
*    of its samples report an identical draw (duplicated noise streams).
*    v(vd0) at those instants is a pure source value -- the DUT does not
*    load an ideal voltage source -- so equal values across two samples can
*    only mean equal random streams.

.options reltol=1e-2 abstol=1e-12

.param vn_na=5.735e-3
.param vn_ts=2e-11
.param od_x=1e-3
.param od_xn={-1*od_x}

vsup vdd 0 dc 1.2
vcm  cm 0 dc {dut_vcm}

* ---- rung 0: zero overdrive (noise-is-actually-injected guard) ----------
vd0  vd0 0 dc 0      trnoise({vn_na} {vn_ts} 0 0)
Eap0 ap0 cm vd0 0 0.5
Ean0 an0 cm vd0 0 -0.5
ib0  vdd ibn0 dc {dut_ib}
X0   ap0 an0 clk ibn0 dout0 doutb0 vdd 0 comparator_dut

* ---- rung +: +od_x --------------------------------------------------------
vd1  vd1 0 dc {od_x}  trnoise({vn_na} {vn_ts} 0 0)
Eap1 ap1 cm vd1 0 0.5
Ean1 an1 cm vd1 0 -0.5
ib1  vdd ibn1 dc {dut_ib}
X1   ap1 an1 clk ibn1 dout1 doutb1 vdd 0 comparator_dut

* ---- rung -: -od_x --------------------------------------------------------
vd2  vd2 0 dc {od_xn} trnoise({vn_na} {vn_ts} 0 0)
Eap2 ap2 cm vd2 0 0.5
Ean2 an2 cm vd2 0 -0.5
ib2  vdd ibn2 dc {dut_ib}
X2   ap2 an2 clk ibn2 dout2 doutb2 vdd 0 comparator_dut

* ---- strobe: original `pulse(0 {vdd_val} 1n 100p 100p 4n 20n)`, scaled ---
vclku clku 0 pulse(0 1 1n 100p 100p 4n 20n)
Bclk  clk  0 v = 'v(clku)*v(vdd)'

* ---- supply-normalized decision probes and their 0/1 binarization --------
Bd0 dn0 0 v = 'v(dout0)/v(vdd)'
Bd1 dn1 0 v = 'v(dout1)/v(vdd)'
Bd2 dn2 0 v = 'v(dout2)/v(vdd)'
Bh0 h0 0 v = 'u(v(dout0)/v(vdd)-0.5)'
Bh1 h1 0 v = 'u(v(dout1)/v(vdd)-0.5)'
Bh2 h2 0 v = 'u(v(dout2)/v(vdd)-0.5)'

* ---- corner-application probe (see regeneration bench) ------------------
Btchk tcheck 0 v = 'temper'
