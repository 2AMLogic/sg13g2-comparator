* offset_mc -- klt sim netlist BODY (sim/klt-corner-verification, issue #62)
* GENERATED by `python3 sim/run_klt_corner_verification.py build` -- do not edit;
* edit the inputs below and rebuild.
*   circuit: sim/klt-corner-verification/benches/offset_mc.circuit.spice  sha256=3f19b447014c6ba39cbf0f0709670011922870161cf688ec7fa9da82f000a15e
*   DUT:     design/comparator.spice  sha256=8bc24f6b8b47f1e83973248496339260189481592681d3c8db26efaa22832ff3
*            sim/dut.json id=comparator-dr0001 provenance=schematic
*   OSDI:    /opt/pdk/ihp-sg13g2/libs.tech/ngspice/osdi
*   OVERRIDE (issue #80 sweep; sim/dut.json untouched): dut_ib=1e-05
*   GEOMETRY OVERRIDE (issue #92 sizing study; design/comparator.spice untouched): XM1.w=8u XM2.w=8u XM3.w=6u XM4.w=6u XM5.w=10u XM6.w=10u XMSW.w=20u
*   base DUT (unmodified) sha256=b31b936dd78634b224d882e5f43ceb3b43eb34e5c3400336f09213cef8a39b90
*
* klt sim netlist-body convention: no .lib / .temp / analysis / .end here --
* klt sim generates those per corner around an .include of this file. The
* .control block below is the one deliberate deviation (see
* sim/kltsim/build.py): SG13G2's MOS models are OSDI and must be
* pre_osdi-loaded before the circuit is parsed, and the pinned klt has no
* request field for that.
.control
pre_osdi /opt/pdk/ihp-sg13g2/libs.tech/ngspice/osdi/psp103.osdi
pre_osdi /opt/pdk/ihp-sg13g2/libs.tech/ngspice/osdi/psp103_nqs.osdi
pre_osdi /opt/pdk/ihp-sg13g2/libs.tech/ngspice/osdi/r3_cmc.osdi
pre_osdi /opt/pdk/ihp-sg13g2/libs.tech/ngspice/osdi/mosvar.osdi
.endc

* ---- DUT operating point (sim/dut.json params) ----
.param dut_ib=1e-05
.param dut_vcm=0.6

* ==== BEGIN DUT design/comparator.spice sha256=8bc24f6b8b47f1e83973248496339260189481592681d3c8db26efaa22832ff3 ====
* ============================================================================
* sg13g2-comparator -- DERIVED NETLIST.  DO NOT EDIT BY HAND.
* ============================================================================
*
* Generated from the xschem sources in design/ by:
*
*     python3 design/netlist.py
*
* The schematics are the source of record:
*
*   design/comparator.sch              the design -- a single-tail StrongARM
*                                      dynamic latch (spec/decision-records/
*                                      0001-comparator-topology.md), plus the
*                                      isolation inverters and NOR SR latch
*                                      that make its outputs HELD between
*                                      strobes as the interface contract
*                                      requires
*   design/comparator_dut.sch          contract wrapper: tail-bias reference
*                                      on the `ibias` pin + the core
*   design/comparator_dut_latch.sch    contract wrapper: the core with its
*                                      tail-bias node tied to vdd
*   design/comparator_dut_analog.sch   the LOOP-BROKEN reduced sub-model --
*                                      an offset/noise LOWER BOUND, not the
*                                      design's front end.  Read
*                                      design/README.md before quoting any
*                                      number measured against it.
*
* Interface contract: sim/dut/README.md.  Asserted at generation time by
* design/netlist.py (against sim/harness/dut.py's own REQUIRED_SUBCKTS) and
* again at load time by the harness.
*
* Parameters supplied by the harness, not by this file: dut_ib, dut_vcm,
* vdd_val, vdd_nom, temp_c (sim/harness/runner.py compose_deck).  This file
* deliberately contains no .include / .lib / .temp / .control / .endc / .end.
* ============================================================================

.subckt comparator vinp vinn clk vbias dout doutb vdd vss
*.iopin vinp
*.iopin vinn
*.iopin clk
*.iopin vbias
*.iopin dout
*.iopin doutb
*.iopin vdd
*.iopin vss
XMT tmid vbias vss vss sg13_lv_nmos w=40u l=0.5u ng=1 m=1
XMSW tail clk tmid vss sg13_lv_nmos w=20u l=0.13u ng=1 m=1
XM1 np vinp tail vss sg13_lv_nmos w=8u l=0.34u ng=1 m=1
XM2 nn vinn tail vss sg13_lv_nmos w=8u l=0.34u ng=1 m=1
XM3 ln lp np vss sg13_lv_nmos w=6u l=0.13u ng=1 m=1
XM4 lp ln nn vss sg13_lv_nmos w=6u l=0.13u ng=1 m=1
XM5 ln lp vdd vdd sg13_lv_pmos w=10u l=0.13u ng=1 m=1
XM6 lp ln vdd vdd sg13_lv_pmos w=10u l=0.13u ng=1 m=1
XM7 ln clk vdd vdd sg13_lv_pmos w=6u l=0.13u ng=1 m=1
XM8 lp clk vdd vdd sg13_lv_pmos w=6u l=0.13u ng=1 m=1
XM9 np clk vdd vdd sg13_lv_pmos w=3u l=0.13u ng=1 m=1
XM10 nn clk vdd vdd sg13_lv_pmos w=3u l=0.13u ng=1 m=1
XMIAP lnb ln vdd vdd sg13_lv_pmos w=3u l=0.13u ng=1 m=1
XMIAN lnb ln vss vss sg13_lv_nmos w=1.5u l=0.13u ng=1 m=1
XMIBP lpb lp vdd vdd sg13_lv_pmos w=3u l=0.13u ng=1 m=1
XMIBN lpb lp vss vss sg13_lv_nmos w=1.5u l=0.13u ng=1 m=1
XMNAP1 na lnb vdd vdd sg13_lv_pmos w=4u l=0.13u ng=1 m=1
XMNAP2 doutb dout na vdd sg13_lv_pmos w=4u l=0.13u ng=1 m=1
XMNAN1 doutb lnb vss vss sg13_lv_nmos w=1.5u l=0.13u ng=1 m=1
XMNAN2 doutb dout vss vss sg13_lv_nmos w=1.5u l=0.13u ng=1 m=1
XMNBP1 nb lpb vdd vdd sg13_lv_pmos w=4u l=0.13u ng=1 m=1
XMNBP2 dout doutb nb vdd sg13_lv_pmos w=4u l=0.13u ng=1 m=1
XMNBN1 dout lpb vss vss sg13_lv_nmos w=1.5u l=0.13u ng=1 m=1
XMNBN2 dout doutb vss vss sg13_lv_nmos w=1.5u l=0.13u ng=1 m=1
.ends

.subckt comparator_dut_analog vinp vinn ibias aop aon vdd vss
*.iopin vinp
*.iopin vinn
*.iopin ibias
*.iopin aop
*.iopin aon
*.iopin vdd
*.iopin vss
XMBA ibias ibias vss vss sg13_lv_nmos w=10u l=0.5u ng=1 m=1
XMTA tmid ibias vss vss sg13_lv_nmos w=40u l=0.5u ng=1 m=1
XMSWA tail vdd tmid vss sg13_lv_nmos w=40u l=0.13u ng=1 m=1
XM1A aon vinp tail vss sg13_lv_nmos w=12u l=0.34u ng=1 m=1
XM2A aop vinn tail vss sg13_lv_nmos w=12u l=0.34u ng=1 m=1
XM5A aon aon vdd vdd sg13_lv_pmos w=3u l=0.13u ng=1 m=1
XM6A aop aop vdd vdd sg13_lv_pmos w=3u l=0.13u ng=1 m=1
.ends

.subckt comparator_dut_latch inp inn clk dout doutb vdd vss
*.iopin inp
*.iopin inn
*.iopin clk
*.iopin dout
*.iopin doutb
*.iopin vdd
*.iopin vss
x1 inp inn clk vdd dout doutb vdd vss comparator
.ends

.subckt comparator_dut vinp vinn clk ibias dout doutb vdd vss
*.iopin vinp
*.iopin vinn
*.iopin clk
*.iopin ibias
*.iopin dout
*.iopin doutb
*.iopin vdd
*.iopin vss
XMB ibias ibias vss vss sg13_lv_nmos w=10u l=0.5u ng=1 m=1
x1 vinp vinn clk ibias dout doutb vdd vss comparator
.ends
* ==== END DUT ====

* ---- bench: offset_mc (klt sim port of sim/comparator-offset-transient-mc)
*
* Whole-latch input-referred offset, one Monte-Carlo draw per klt sim
* sample. Circuit is sim/comparator-offset-transient-mc/testbench/
* tb_offset_transient_mc.spice's (a single comparator_dut driven by a
* 33-level, -48 ... +48 mV, 3 mV/step, 30 ns/step differential staircase),
* carried over element for element, with one structural change forced by
* klt sim's supply axis: the clock is a unit pulse scaled by the live
* supply node (Bclk), because `alter vsup=<V>` does not reach the original
* `pulse(0 {vdd_val} ...)` amplitude.
*
* WHAT MOVES FROM THE DECK INTO klt sim. The original bench ran its 60
* draws inside one ngspice process (`setseed 20260916`, a `dowhile` loop of
* `reset` + `tran`) and reduced them in-deck. Here klt sim owns the draw
* loop: `monte_carlo.n` samples per corner, each a separate ngspice process
* whose `.options seed=` card klt derives from `monte_carlo.seed` (klt's
* SHA-256 seed contract), and the per-draw offset is one `.meas ... param=`
* in the request. The mismatch switch is still the corner section
* (`mos_<p>_mismatch` of cornerMOSlv.lib), exactly as before. The draws
* are therefore a different realization of the same statistical basis
* (whole latch, mismatch models, N per point), not a bit-identical replay.

.options reltol=1e-4 vntol=1e-9 abstol=1e-13

.param c_route=10f

vsup vdd 0 dc 1.2

vcm cm 0 dc {dut_vcm}
vd   vd 0 pwl(
+ 0.0000n -0.048 29.8000n -0.048 30.0000n -0.045 59.8000n -0.045
+ 60.0000n -0.042 89.8000n -0.042 90.0000n -0.039 119.8000n -0.039
+ 120.0000n -0.036 149.8000n -0.036 150.0000n -0.033 179.8000n -0.033
+ 180.0000n -0.03 209.8000n -0.03 210.0000n -0.027 239.8000n -0.027
+ 240.0000n -0.024 269.8000n -0.024 270.0000n -0.021 299.8000n -0.021
+ 300.0000n -0.018 329.8000n -0.018 330.0000n -0.015 359.8000n -0.015
+ 360.0000n -0.012 389.8000n -0.012 390.0000n -0.009 419.8000n -0.009
+ 420.0000n -0.006 449.8000n -0.006 450.0000n -0.003 479.8000n -0.003
+ 480.0000n 0 509.8000n 0 510.0000n 0.003 539.8000n 0.003
+ 540.0000n 0.006 569.8000n 0.006 570.0000n 0.009 599.8000n 0.009
+ 600.0000n 0.012 629.8000n 0.012 630.0000n 0.015 659.8000n 0.015
+ 660.0000n 0.018 689.8000n 0.018 690.0000n 0.021 719.8000n 0.021
+ 720.0000n 0.024 749.8000n 0.024 750.0000n 0.027 779.8000n 0.027
+ 780.0000n 0.03 809.8000n 0.03 810.0000n 0.033 839.8000n 0.033
+ 840.0000n 0.036 869.8000n 0.036 870.0000n 0.039 899.8000n 0.039
+ 900.0000n 0.042 929.8000n 0.042 930.0000n 0.045 959.8000n 0.045
+ 960.0000n 0.048 989.8000n 0.048 990.0000n 0.048
+ )
Eap ap cm vd 0 0.5
Ean an cm vd 0 -0.5

* one strobe per 30 ns step (original: pulse(0 {vdd_val} 10n 100p 100p 10n
* 30n)), scaled by the altered supply
vclku clku 0 pulse(0 1 10n 100p 100p 10n 30n)
Bclk  clk  0 v = 'v(clku)*v(vdd)'

ib   vdd ibn dc {dut_ib}
Xa   ap an clk ibn dout doutb vdd 0 comparator_dut
Cwd  dout 0 {c_route}

Bdoutn doutn 0 v = 'v(dout)/v(vdd)'

* ---- corner-application probe (see regeneration bench) ------------------
Btchk tcheck 0 v = 'temper'

* ---- per-level decision reads (as in the original tb.json analyses) ------
* One `find` per staircase level, 3 ns before that level's step ends (the
* original deck's `meas tran dlevK find v(doutn) at=...` lines, verbatim
* times). They live in the BODY, not the request, only to keep the
* envelope small (2700 samples x 33 reads); every value still prints to the
* per-sample ngspice log, and the request's `lowcount`/`vos_mv` measurements
* are computed from them by ngspice itself (`.meas ... param=`).
.meas tran dlev0 find v(doutn) at=27.0000n
.meas tran dlev1 find v(doutn) at=57.0000n
.meas tran dlev2 find v(doutn) at=87.0000n
.meas tran dlev3 find v(doutn) at=117.0000n
.meas tran dlev4 find v(doutn) at=147.0000n
.meas tran dlev5 find v(doutn) at=177.0000n
.meas tran dlev6 find v(doutn) at=207.0000n
.meas tran dlev7 find v(doutn) at=237.0000n
.meas tran dlev8 find v(doutn) at=267.0000n
.meas tran dlev9 find v(doutn) at=297.0000n
.meas tran dlev10 find v(doutn) at=327.0000n
.meas tran dlev11 find v(doutn) at=357.0000n
.meas tran dlev12 find v(doutn) at=387.0000n
.meas tran dlev13 find v(doutn) at=417.0000n
.meas tran dlev14 find v(doutn) at=447.0000n
.meas tran dlev15 find v(doutn) at=477.0000n
.meas tran dlev16 find v(doutn) at=507.0000n
.meas tran dlev17 find v(doutn) at=537.0000n
.meas tran dlev18 find v(doutn) at=567.0000n
.meas tran dlev19 find v(doutn) at=597.0000n
.meas tran dlev20 find v(doutn) at=627.0000n
.meas tran dlev21 find v(doutn) at=657.0000n
.meas tran dlev22 find v(doutn) at=687.0000n
.meas tran dlev23 find v(doutn) at=717.0000n
.meas tran dlev24 find v(doutn) at=747.0000n
.meas tran dlev25 find v(doutn) at=777.0000n
.meas tran dlev26 find v(doutn) at=807.0000n
.meas tran dlev27 find v(doutn) at=837.0000n
.meas tran dlev28 find v(doutn) at=867.0000n
.meas tran dlev29 find v(doutn) at=897.0000n
.meas tran dlev30 find v(doutn) at=927.0000n
.meas tran dlev31 find v(doutn) at=957.0000n
.meas tran dlev32 find v(doutn) at=987.0000n
