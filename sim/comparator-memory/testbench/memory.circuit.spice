* ---- bench: memory / hysteresis (issue #159) ---------------------------
* Two histories in ONE netlist: P (3 strobes at +50 mV, then the probe) and
* N (3 strobes at -50 mV, then the SAME probe grid), each probe on its own
* DUT instance from the same clock and supply. The probe differential for
* instance m is lo + m*step (integer uV); `lo` is looked up per PVT point from
* the committed bracket of the previous round, `step` is the round's fixed
* spacing. The probe actually applied is measured (s_<h>_<m>) and checked
* against the plan, so a wrong lookup rejects the point instead of misreporting.
* clock: 10 ns high, period 30 ns (reset 20 ns);
* decision sampled 9 ns after the fourth rising edge
* (t = 109 ns).
.options reltol=1e-6 vntol=1e-9 abstol=1e-13

vsup  vdd  0 dc 1.2
vclku clku 0 pulse(0 1 10n 100p 100p 10n 30n)
Bclk  clk  0 v = 'v(clku)*v(vdd)'
vcm   cm   0 dc {dut_vcm}
vsw   sw   0 pwl(0 0 80.3n 0 80.4n 1)
vcp   cp   0 dc 0.05
vcn   cn   0 dc -0.05
Btchk tcheck 0 v = 'temper'
BloP   loP   0 v = '-50000'
BloN   loN   0 v = '-50000'

* history P, probe multiplier 0
BsP0 sP0 0 v = 'v(cp)*(1-v(sw)) + (v(loP)+0*10000)*1e-6*v(sw)'
EapP0 apP0 cm sP0 0 0.5
EanP0 anP0 cm sP0 0 -0.5
ibP0  vdd ibnP0 dc {dut_ib}
XP0   apP0 anP0 clk ibnP0 doutP0 doutbP0 vdd 0 comparator_dut
BdP0 dP0 0 v = '(v(doutP0)-v(doutbP0))/v(vdd)'
* history P, probe multiplier 1
BsP1 sP1 0 v = 'v(cp)*(1-v(sw)) + (v(loP)+1*10000)*1e-6*v(sw)'
EapP1 apP1 cm sP1 0 0.5
EanP1 anP1 cm sP1 0 -0.5
ibP1  vdd ibnP1 dc {dut_ib}
XP1   apP1 anP1 clk ibnP1 doutP1 doutbP1 vdd 0 comparator_dut
BdP1 dP1 0 v = '(v(doutP1)-v(doutbP1))/v(vdd)'
* history P, probe multiplier 2
BsP2 sP2 0 v = 'v(cp)*(1-v(sw)) + (v(loP)+2*10000)*1e-6*v(sw)'
EapP2 apP2 cm sP2 0 0.5
EanP2 anP2 cm sP2 0 -0.5
ibP2  vdd ibnP2 dc {dut_ib}
XP2   apP2 anP2 clk ibnP2 doutP2 doutbP2 vdd 0 comparator_dut
BdP2 dP2 0 v = '(v(doutP2)-v(doutbP2))/v(vdd)'
* history P, probe multiplier 3
BsP3 sP3 0 v = 'v(cp)*(1-v(sw)) + (v(loP)+3*10000)*1e-6*v(sw)'
EapP3 apP3 cm sP3 0 0.5
EanP3 anP3 cm sP3 0 -0.5
ibP3  vdd ibnP3 dc {dut_ib}
XP3   apP3 anP3 clk ibnP3 doutP3 doutbP3 vdd 0 comparator_dut
BdP3 dP3 0 v = '(v(doutP3)-v(doutbP3))/v(vdd)'
* history P, probe multiplier 4
BsP4 sP4 0 v = 'v(cp)*(1-v(sw)) + (v(loP)+4*10000)*1e-6*v(sw)'
EapP4 apP4 cm sP4 0 0.5
EanP4 anP4 cm sP4 0 -0.5
ibP4  vdd ibnP4 dc {dut_ib}
XP4   apP4 anP4 clk ibnP4 doutP4 doutbP4 vdd 0 comparator_dut
BdP4 dP4 0 v = '(v(doutP4)-v(doutbP4))/v(vdd)'
* history P, probe multiplier 5
BsP5 sP5 0 v = 'v(cp)*(1-v(sw)) + (v(loP)+5*10000)*1e-6*v(sw)'
EapP5 apP5 cm sP5 0 0.5
EanP5 anP5 cm sP5 0 -0.5
ibP5  vdd ibnP5 dc {dut_ib}
XP5   apP5 anP5 clk ibnP5 doutP5 doutbP5 vdd 0 comparator_dut
BdP5 dP5 0 v = '(v(doutP5)-v(doutbP5))/v(vdd)'
* history P, probe multiplier 6
BsP6 sP6 0 v = 'v(cp)*(1-v(sw)) + (v(loP)+6*10000)*1e-6*v(sw)'
EapP6 apP6 cm sP6 0 0.5
EanP6 anP6 cm sP6 0 -0.5
ibP6  vdd ibnP6 dc {dut_ib}
XP6   apP6 anP6 clk ibnP6 doutP6 doutbP6 vdd 0 comparator_dut
BdP6 dP6 0 v = '(v(doutP6)-v(doutbP6))/v(vdd)'
* history P, probe multiplier 7
BsP7 sP7 0 v = 'v(cp)*(1-v(sw)) + (v(loP)+7*10000)*1e-6*v(sw)'
EapP7 apP7 cm sP7 0 0.5
EanP7 anP7 cm sP7 0 -0.5
ibP7  vdd ibnP7 dc {dut_ib}
XP7   apP7 anP7 clk ibnP7 doutP7 doutbP7 vdd 0 comparator_dut
BdP7 dP7 0 v = '(v(doutP7)-v(doutbP7))/v(vdd)'
* history P, probe multiplier 8
BsP8 sP8 0 v = 'v(cp)*(1-v(sw)) + (v(loP)+8*10000)*1e-6*v(sw)'
EapP8 apP8 cm sP8 0 0.5
EanP8 anP8 cm sP8 0 -0.5
ibP8  vdd ibnP8 dc {dut_ib}
XP8   apP8 anP8 clk ibnP8 doutP8 doutbP8 vdd 0 comparator_dut
BdP8 dP8 0 v = '(v(doutP8)-v(doutbP8))/v(vdd)'
* history P, probe multiplier 9
BsP9 sP9 0 v = 'v(cp)*(1-v(sw)) + (v(loP)+9*10000)*1e-6*v(sw)'
EapP9 apP9 cm sP9 0 0.5
EanP9 anP9 cm sP9 0 -0.5
ibP9  vdd ibnP9 dc {dut_ib}
XP9   apP9 anP9 clk ibnP9 doutP9 doutbP9 vdd 0 comparator_dut
BdP9 dP9 0 v = '(v(doutP9)-v(doutbP9))/v(vdd)'
* history P, probe multiplier 10
BsP10 sP10 0 v = 'v(cp)*(1-v(sw)) + (v(loP)+10*10000)*1e-6*v(sw)'
EapP10 apP10 cm sP10 0 0.5
EanP10 anP10 cm sP10 0 -0.5
ibP10  vdd ibnP10 dc {dut_ib}
XP10   apP10 anP10 clk ibnP10 doutP10 doutbP10 vdd 0 comparator_dut
BdP10 dP10 0 v = '(v(doutP10)-v(doutbP10))/v(vdd)'
* history N, probe multiplier 0
BsN0 sN0 0 v = 'v(cn)*(1-v(sw)) + (v(loN)+0*10000)*1e-6*v(sw)'
EapN0 apN0 cm sN0 0 0.5
EanN0 anN0 cm sN0 0 -0.5
ibN0  vdd ibnN0 dc {dut_ib}
XN0   apN0 anN0 clk ibnN0 doutN0 doutbN0 vdd 0 comparator_dut
BdN0 dN0 0 v = '(v(doutN0)-v(doutbN0))/v(vdd)'
* history N, probe multiplier 1
BsN1 sN1 0 v = 'v(cn)*(1-v(sw)) + (v(loN)+1*10000)*1e-6*v(sw)'
EapN1 apN1 cm sN1 0 0.5
EanN1 anN1 cm sN1 0 -0.5
ibN1  vdd ibnN1 dc {dut_ib}
XN1   apN1 anN1 clk ibnN1 doutN1 doutbN1 vdd 0 comparator_dut
BdN1 dN1 0 v = '(v(doutN1)-v(doutbN1))/v(vdd)'
* history N, probe multiplier 2
BsN2 sN2 0 v = 'v(cn)*(1-v(sw)) + (v(loN)+2*10000)*1e-6*v(sw)'
EapN2 apN2 cm sN2 0 0.5
EanN2 anN2 cm sN2 0 -0.5
ibN2  vdd ibnN2 dc {dut_ib}
XN2   apN2 anN2 clk ibnN2 doutN2 doutbN2 vdd 0 comparator_dut
BdN2 dN2 0 v = '(v(doutN2)-v(doutbN2))/v(vdd)'
* history N, probe multiplier 3
BsN3 sN3 0 v = 'v(cn)*(1-v(sw)) + (v(loN)+3*10000)*1e-6*v(sw)'
EapN3 apN3 cm sN3 0 0.5
EanN3 anN3 cm sN3 0 -0.5
ibN3  vdd ibnN3 dc {dut_ib}
XN3   apN3 anN3 clk ibnN3 doutN3 doutbN3 vdd 0 comparator_dut
BdN3 dN3 0 v = '(v(doutN3)-v(doutbN3))/v(vdd)'
* history N, probe multiplier 4
BsN4 sN4 0 v = 'v(cn)*(1-v(sw)) + (v(loN)+4*10000)*1e-6*v(sw)'
EapN4 apN4 cm sN4 0 0.5
EanN4 anN4 cm sN4 0 -0.5
ibN4  vdd ibnN4 dc {dut_ib}
XN4   apN4 anN4 clk ibnN4 doutN4 doutbN4 vdd 0 comparator_dut
BdN4 dN4 0 v = '(v(doutN4)-v(doutbN4))/v(vdd)'
* history N, probe multiplier 5
BsN5 sN5 0 v = 'v(cn)*(1-v(sw)) + (v(loN)+5*10000)*1e-6*v(sw)'
EapN5 apN5 cm sN5 0 0.5
EanN5 anN5 cm sN5 0 -0.5
ibN5  vdd ibnN5 dc {dut_ib}
XN5   apN5 anN5 clk ibnN5 doutN5 doutbN5 vdd 0 comparator_dut
BdN5 dN5 0 v = '(v(doutN5)-v(doutbN5))/v(vdd)'
* history N, probe multiplier 6
BsN6 sN6 0 v = 'v(cn)*(1-v(sw)) + (v(loN)+6*10000)*1e-6*v(sw)'
EapN6 apN6 cm sN6 0 0.5
EanN6 anN6 cm sN6 0 -0.5
ibN6  vdd ibnN6 dc {dut_ib}
XN6   apN6 anN6 clk ibnN6 doutN6 doutbN6 vdd 0 comparator_dut
BdN6 dN6 0 v = '(v(doutN6)-v(doutbN6))/v(vdd)'
* history N, probe multiplier 7
BsN7 sN7 0 v = 'v(cn)*(1-v(sw)) + (v(loN)+7*10000)*1e-6*v(sw)'
EapN7 apN7 cm sN7 0 0.5
EanN7 anN7 cm sN7 0 -0.5
ibN7  vdd ibnN7 dc {dut_ib}
XN7   apN7 anN7 clk ibnN7 doutN7 doutbN7 vdd 0 comparator_dut
BdN7 dN7 0 v = '(v(doutN7)-v(doutbN7))/v(vdd)'
* history N, probe multiplier 8
BsN8 sN8 0 v = 'v(cn)*(1-v(sw)) + (v(loN)+8*10000)*1e-6*v(sw)'
EapN8 apN8 cm sN8 0 0.5
EanN8 anN8 cm sN8 0 -0.5
ibN8  vdd ibnN8 dc {dut_ib}
XN8   apN8 anN8 clk ibnN8 doutN8 doutbN8 vdd 0 comparator_dut
BdN8 dN8 0 v = '(v(doutN8)-v(doutbN8))/v(vdd)'
* history N, probe multiplier 9
BsN9 sN9 0 v = 'v(cn)*(1-v(sw)) + (v(loN)+9*10000)*1e-6*v(sw)'
EapN9 apN9 cm sN9 0 0.5
EanN9 anN9 cm sN9 0 -0.5
ibN9  vdd ibnN9 dc {dut_ib}
XN9   apN9 anN9 clk ibnN9 doutN9 doutbN9 vdd 0 comparator_dut
BdN9 dN9 0 v = '(v(doutN9)-v(doutbN9))/v(vdd)'
* history N, probe multiplier 10
BsN10 sN10 0 v = 'v(cn)*(1-v(sw)) + (v(loN)+10*10000)*1e-6*v(sw)'
EapN10 apN10 cm sN10 0 0.5
EanN10 anN10 cm sN10 0 -0.5
ibN10  vdd ibnN10 dc {dut_ib}
XN10   apN10 anN10 clk ibnN10 doutN10 doutbN10 vdd 0 comparator_dut
BdN10 dN10 0 v = '(v(doutN10)-v(doutbN10))/v(vdd)'
