* memory nominal round 2 mos_tt -- klt sim netlist BODY (sim/comparator-memory, issue #159)
* GENERATED by `python3 sim/run_memory.py` (sim/kltsim/memory.py) -- do not edit.
*   circuit sha256=f3a73817c292e8eb52b1207466709815ec0116a1133dd26dc631b79dedbc7776
*   DUT:     design/comparator.spice  sha256=b31b936dd78634b224d882e5f43ceb3b43eb34e5c3400336f09213cef8a39b90
*            sim/dut.json id=comparator-dr0001 provenance=schematic
*   OSDI:    /opt/pdk/ihp-sg13g2/libs.tech/ngspice/osdi
*
* klt sim netlist-body convention: no .lib / .temp / analysis / .end here.
* The .control block is the one deliberate deviation (see sim/kltsim/build.py):
* SG13G2's MOS models are OSDI and must be pre_osdi-loaded.
.control
pre_osdi /opt/pdk/ihp-sg13g2/libs.tech/ngspice/osdi/psp103.osdi
pre_osdi /opt/pdk/ihp-sg13g2/libs.tech/ngspice/osdi/psp103_nqs.osdi
pre_osdi /opt/pdk/ihp-sg13g2/libs.tech/ngspice/osdi/r3_cmc.osdi
pre_osdi /opt/pdk/ihp-sg13g2/libs.tech/ngspice/osdi/mosvar.osdi
.endc

* ---- DUT operating point (sim/dut.json params) ----
.param dut_ib=2e-05
.param dut_vcm=0.6

* ==== BEGIN DUT design/comparator.spice sha256=b31b936dd78634b224d882e5f43ceb3b43eb34e5c3400336f09213cef8a39b90 ====
* ============================================================================
* sg13g2-comparator -- DERIVED NETLIST.  DO NOT EDIT BY HAND.
* ============================================================================
*
* Generated from the xschem sources in design/ by:
*
*     python3 design/netlist.py
*
* The schematics are the source of record:
*
*   design/comparator.sch              the design -- a single-tail StrongARM
*                                      dynamic latch (spec/decision-records/
*                                      0001-comparator-topology.md), plus the
*                                      isolation inverters and NOR SR latch
*                                      that make its outputs HELD between
*                                      strobes as the interface contract
*                                      requires
*   design/comparator_dut.sch          contract wrapper: tail-bias reference
*                                      on the `ibias` pin + the core
*   design/comparator_dut_latch.sch    contract wrapper: the core with its
*                                      tail-bias node tied to vdd
*   design/comparator_dut_analog.sch   the LOOP-BROKEN reduced sub-model --
*                                      an offset/noise LOWER BOUND, not the
*                                      design's front end.  Read
*                                      design/README.md before quoting any
*                                      number measured against it.
*
* Interface contract: sim/dut/README.md.  Asserted at generation time by
* design/netlist.py (against sim/harness/dut.py's own REQUIRED_SUBCKTS) and
* again at load time by the harness.
*
* Parameters supplied by the harness, not by this file: dut_ib, dut_vcm,
* vdd_val, vdd_nom, temp_c (sim/harness/runner.py compose_deck).  This file
* deliberately contains no .include / .lib / .temp / .control / .endc / .end.
* ============================================================================

.subckt comparator vinp vinn clk vbias dout doutb vdd vss
*.iopin vinp
*.iopin vinn
*.iopin clk
*.iopin vbias
*.iopin dout
*.iopin doutb
*.iopin vdd
*.iopin vss
XMT tmid vbias vss vss sg13_lv_nmos w=40u l=0.5u ng=1 m=1
XMSW tail clk tmid vss sg13_lv_nmos w=40u l=0.13u ng=1 m=1
XM1 np vinp tail vss sg13_lv_nmos w=12u l=0.34u ng=1 m=1
XM2 nn vinn tail vss sg13_lv_nmos w=12u l=0.34u ng=1 m=1
XM3 ln lp np vss sg13_lv_nmos w=3u l=0.13u ng=1 m=1
XM4 lp ln nn vss sg13_lv_nmos w=3u l=0.13u ng=1 m=1
XM5 ln lp vdd vdd sg13_lv_pmos w=3u l=0.13u ng=1 m=1
XM6 lp ln vdd vdd sg13_lv_pmos w=3u l=0.13u ng=1 m=1
XM7 ln clk vdd vdd sg13_lv_pmos w=6u l=0.13u ng=1 m=1
XM8 lp clk vdd vdd sg13_lv_pmos w=6u l=0.13u ng=1 m=1
XM9 np clk vdd vdd sg13_lv_pmos w=3u l=0.13u ng=1 m=1
XM10 nn clk vdd vdd sg13_lv_pmos w=3u l=0.13u ng=1 m=1
XMIAP lnb ln vdd vdd sg13_lv_pmos w=3u l=0.13u ng=1 m=1
XMIAN lnb ln vss vss sg13_lv_nmos w=1.5u l=0.13u ng=1 m=1
XMIBP lpb lp vdd vdd sg13_lv_pmos w=3u l=0.13u ng=1 m=1
XMIBN lpb lp vss vss sg13_lv_nmos w=1.5u l=0.13u ng=1 m=1
XMNAP1 na lnb vdd vdd sg13_lv_pmos w=4u l=0.13u ng=1 m=1
XMNAP2 doutb dout na vdd sg13_lv_pmos w=4u l=0.13u ng=1 m=1
XMNAN1 doutb lnb vss vss sg13_lv_nmos w=1.5u l=0.13u ng=1 m=1
XMNAN2 doutb dout vss vss sg13_lv_nmos w=1.5u l=0.13u ng=1 m=1
XMNBP1 nb lpb vdd vdd sg13_lv_pmos w=4u l=0.13u ng=1 m=1
XMNBP2 dout doutb nb vdd sg13_lv_pmos w=4u l=0.13u ng=1 m=1
XMNBN1 dout lpb vss vss sg13_lv_nmos w=1.5u l=0.13u ng=1 m=1
XMNBN2 dout doutb vss vss sg13_lv_nmos w=1.5u l=0.13u ng=1 m=1
.ends

.subckt comparator_dut_analog vinp vinn ibias aop aon vdd vss
*.iopin vinp
*.iopin vinn
*.iopin ibias
*.iopin aop
*.iopin aon
*.iopin vdd
*.iopin vss
XMBA ibias ibias vss vss sg13_lv_nmos w=10u l=0.5u ng=1 m=1
XMTA tmid ibias vss vss sg13_lv_nmos w=40u l=0.5u ng=1 m=1
XMSWA tail vdd tmid vss sg13_lv_nmos w=40u l=0.13u ng=1 m=1
XM1A aon vinp tail vss sg13_lv_nmos w=12u l=0.34u ng=1 m=1
XM2A aop vinn tail vss sg13_lv_nmos w=12u l=0.34u ng=1 m=1
XM5A aon aon vdd vdd sg13_lv_pmos w=3u l=0.13u ng=1 m=1
XM6A aop aop vdd vdd sg13_lv_pmos w=3u l=0.13u ng=1 m=1
.ends

.subckt comparator_dut_latch inp inn clk dout doutb vdd vss
*.iopin inp
*.iopin inn
*.iopin clk
*.iopin dout
*.iopin doutb
*.iopin vdd
*.iopin vss
x1 inp inn clk vdd dout doutb vdd vss comparator
.ends

.subckt comparator_dut vinp vinn clk ibias dout doutb vdd vss
*.iopin vinp
*.iopin vinn
*.iopin clk
*.iopin ibias
*.iopin dout
*.iopin doutb
*.iopin vdd
*.iopin vss
XMB ibias ibias vss vss sg13_lv_nmos w=10u l=0.5u ng=1 m=1
x1 vinp vinn clk ibias dout doutb vdd vss comparator
.ends
* ==== END DUT ====

* ---- bench: memory / hysteresis (issue #159) ---------------------------
* Two histories in ONE netlist: P (3 strobes at +50 mV, then the probe) and
* N (3 strobes at -50 mV, then the SAME probe grid), each probe on its own
* DUT instance from the same clock and supply. The probe differential for
* instance m is lo + m*step (integer uV); `lo` is looked up per PVT point from
* the committed bracket of the previous round, `step` is the round's fixed
* spacing. The probe actually applied is measured (s_<h>_<m>) and checked
* against the plan, so a wrong lookup rejects the point instead of misreporting.
* clock: 10 ns high, period 30 ns (reset 20 ns);
* decision sampled 9 ns after the fourth rising edge
* (t = 109 ns).
.options reltol=1e-6 vntol=1e-9 abstol=1e-13

vsup  vdd  0 dc 1.2
vclku clku 0 pulse(0 1 10n 100p 100p 10n 30n)
Bclk  clk  0 v = 'v(clku)*v(vdd)'
vcm   cm   0 dc {dut_vcm}
vsw   sw   0 pwl(0 0 80.3n 0 80.4n 1)
vcp   cp   0 dc 0.05
vcn   cn   0 dc -0.05
Btchk tcheck 0 v = 'temper'
BloP   loP   0 v = '-10000'
BloN   loN   0 v = '0'

* history P, probe multiplier 1
BsP1 sP1 0 v = 'v(cp)*(1-v(sw)) + (v(loP)+1*1000)*1e-6*v(sw)'
EapP1 apP1 cm sP1 0 0.5
EanP1 anP1 cm sP1 0 -0.5
ibP1  vdd ibnP1 dc {dut_ib}
XP1   apP1 anP1 clk ibnP1 doutP1 doutbP1 vdd 0 comparator_dut
BdP1 dP1 0 v = '(v(doutP1)-v(doutbP1))/v(vdd)'
* history P, probe multiplier 2
BsP2 sP2 0 v = 'v(cp)*(1-v(sw)) + (v(loP)+2*1000)*1e-6*v(sw)'
EapP2 apP2 cm sP2 0 0.5
EanP2 anP2 cm sP2 0 -0.5
ibP2  vdd ibnP2 dc {dut_ib}
XP2   apP2 anP2 clk ibnP2 doutP2 doutbP2 vdd 0 comparator_dut
BdP2 dP2 0 v = '(v(doutP2)-v(doutbP2))/v(vdd)'
* history P, probe multiplier 3
BsP3 sP3 0 v = 'v(cp)*(1-v(sw)) + (v(loP)+3*1000)*1e-6*v(sw)'
EapP3 apP3 cm sP3 0 0.5
EanP3 anP3 cm sP3 0 -0.5
ibP3  vdd ibnP3 dc {dut_ib}
XP3   apP3 anP3 clk ibnP3 doutP3 doutbP3 vdd 0 comparator_dut
BdP3 dP3 0 v = '(v(doutP3)-v(doutbP3))/v(vdd)'
* history P, probe multiplier 4
BsP4 sP4 0 v = 'v(cp)*(1-v(sw)) + (v(loP)+4*1000)*1e-6*v(sw)'
EapP4 apP4 cm sP4 0 0.5
EanP4 anP4 cm sP4 0 -0.5
ibP4  vdd ibnP4 dc {dut_ib}
XP4   apP4 anP4 clk ibnP4 doutP4 doutbP4 vdd 0 comparator_dut
BdP4 dP4 0 v = '(v(doutP4)-v(doutbP4))/v(vdd)'
* history P, probe multiplier 5
BsP5 sP5 0 v = 'v(cp)*(1-v(sw)) + (v(loP)+5*1000)*1e-6*v(sw)'
EapP5 apP5 cm sP5 0 0.5
EanP5 anP5 cm sP5 0 -0.5
ibP5  vdd ibnP5 dc {dut_ib}
XP5   apP5 anP5 clk ibnP5 doutP5 doutbP5 vdd 0 comparator_dut
BdP5 dP5 0 v = '(v(doutP5)-v(doutbP5))/v(vdd)'
* history P, probe multiplier 6
BsP6 sP6 0 v = 'v(cp)*(1-v(sw)) + (v(loP)+6*1000)*1e-6*v(sw)'
EapP6 apP6 cm sP6 0 0.5
EanP6 anP6 cm sP6 0 -0.5
ibP6  vdd ibnP6 dc {dut_ib}
XP6   apP6 anP6 clk ibnP6 doutP6 doutbP6 vdd 0 comparator_dut
BdP6 dP6 0 v = '(v(doutP6)-v(doutbP6))/v(vdd)'
* history P, probe multiplier 7
BsP7 sP7 0 v = 'v(cp)*(1-v(sw)) + (v(loP)+7*1000)*1e-6*v(sw)'
EapP7 apP7 cm sP7 0 0.5
EanP7 anP7 cm sP7 0 -0.5
ibP7  vdd ibnP7 dc {dut_ib}
XP7   apP7 anP7 clk ibnP7 doutP7 doutbP7 vdd 0 comparator_dut
BdP7 dP7 0 v = '(v(doutP7)-v(doutbP7))/v(vdd)'
* history P, probe multiplier 8
BsP8 sP8 0 v = 'v(cp)*(1-v(sw)) + (v(loP)+8*1000)*1e-6*v(sw)'
EapP8 apP8 cm sP8 0 0.5
EanP8 anP8 cm sP8 0 -0.5
ibP8  vdd ibnP8 dc {dut_ib}
XP8   apP8 anP8 clk ibnP8 doutP8 doutbP8 vdd 0 comparator_dut
BdP8 dP8 0 v = '(v(doutP8)-v(doutbP8))/v(vdd)'
* history P, probe multiplier 9
BsP9 sP9 0 v = 'v(cp)*(1-v(sw)) + (v(loP)+9*1000)*1e-6*v(sw)'
EapP9 apP9 cm sP9 0 0.5
EanP9 anP9 cm sP9 0 -0.5
ibP9  vdd ibnP9 dc {dut_ib}
XP9   apP9 anP9 clk ibnP9 doutP9 doutbP9 vdd 0 comparator_dut
BdP9 dP9 0 v = '(v(doutP9)-v(doutbP9))/v(vdd)'
* history N, probe multiplier 1
BsN1 sN1 0 v = 'v(cn)*(1-v(sw)) + (v(loN)+1*1000)*1e-6*v(sw)'
EapN1 apN1 cm sN1 0 0.5
EanN1 anN1 cm sN1 0 -0.5
ibN1  vdd ibnN1 dc {dut_ib}
XN1   apN1 anN1 clk ibnN1 doutN1 doutbN1 vdd 0 comparator_dut
BdN1 dN1 0 v = '(v(doutN1)-v(doutbN1))/v(vdd)'
* history N, probe multiplier 2
BsN2 sN2 0 v = 'v(cn)*(1-v(sw)) + (v(loN)+2*1000)*1e-6*v(sw)'
EapN2 apN2 cm sN2 0 0.5
EanN2 anN2 cm sN2 0 -0.5
ibN2  vdd ibnN2 dc {dut_ib}
XN2   apN2 anN2 clk ibnN2 doutN2 doutbN2 vdd 0 comparator_dut
BdN2 dN2 0 v = '(v(doutN2)-v(doutbN2))/v(vdd)'
* history N, probe multiplier 3
BsN3 sN3 0 v = 'v(cn)*(1-v(sw)) + (v(loN)+3*1000)*1e-6*v(sw)'
EapN3 apN3 cm sN3 0 0.5
EanN3 anN3 cm sN3 0 -0.5
ibN3  vdd ibnN3 dc {dut_ib}
XN3   apN3 anN3 clk ibnN3 doutN3 doutbN3 vdd 0 comparator_dut
BdN3 dN3 0 v = '(v(doutN3)-v(doutbN3))/v(vdd)'
* history N, probe multiplier 4
BsN4 sN4 0 v = 'v(cn)*(1-v(sw)) + (v(loN)+4*1000)*1e-6*v(sw)'
EapN4 apN4 cm sN4 0 0.5
EanN4 anN4 cm sN4 0 -0.5
ibN4  vdd ibnN4 dc {dut_ib}
XN4   apN4 anN4 clk ibnN4 doutN4 doutbN4 vdd 0 comparator_dut
BdN4 dN4 0 v = '(v(doutN4)-v(doutbN4))/v(vdd)'
* history N, probe multiplier 5
BsN5 sN5 0 v = 'v(cn)*(1-v(sw)) + (v(loN)+5*1000)*1e-6*v(sw)'
EapN5 apN5 cm sN5 0 0.5
EanN5 anN5 cm sN5 0 -0.5
ibN5  vdd ibnN5 dc {dut_ib}
XN5   apN5 anN5 clk ibnN5 doutN5 doutbN5 vdd 0 comparator_dut
BdN5 dN5 0 v = '(v(doutN5)-v(doutbN5))/v(vdd)'
* history N, probe multiplier 6
BsN6 sN6 0 v = 'v(cn)*(1-v(sw)) + (v(loN)+6*1000)*1e-6*v(sw)'
EapN6 apN6 cm sN6 0 0.5
EanN6 anN6 cm sN6 0 -0.5
ibN6  vdd ibnN6 dc {dut_ib}
XN6   apN6 anN6 clk ibnN6 doutN6 doutbN6 vdd 0 comparator_dut
BdN6 dN6 0 v = '(v(doutN6)-v(doutbN6))/v(vdd)'
* history N, probe multiplier 7
BsN7 sN7 0 v = 'v(cn)*(1-v(sw)) + (v(loN)+7*1000)*1e-6*v(sw)'
EapN7 apN7 cm sN7 0 0.5
EanN7 anN7 cm sN7 0 -0.5
ibN7  vdd ibnN7 dc {dut_ib}
XN7   apN7 anN7 clk ibnN7 doutN7 doutbN7 vdd 0 comparator_dut
BdN7 dN7 0 v = '(v(doutN7)-v(doutbN7))/v(vdd)'
* history N, probe multiplier 8
BsN8 sN8 0 v = 'v(cn)*(1-v(sw)) + (v(loN)+8*1000)*1e-6*v(sw)'
EapN8 apN8 cm sN8 0 0.5
EanN8 anN8 cm sN8 0 -0.5
ibN8  vdd ibnN8 dc {dut_ib}
XN8   apN8 anN8 clk ibnN8 doutN8 doutbN8 vdd 0 comparator_dut
BdN8 dN8 0 v = '(v(doutN8)-v(doutbN8))/v(vdd)'
* history N, probe multiplier 9
BsN9 sN9 0 v = 'v(cn)*(1-v(sw)) + (v(loN)+9*1000)*1e-6*v(sw)'
EapN9 apN9 cm sN9 0 0.5
EanN9 anN9 cm sN9 0 -0.5
ibN9  vdd ibnN9 dc {dut_ib}
XN9   apN9 anN9 clk ibnN9 doutN9 doutbN9 vdd 0 comparator_dut
BdN9 dN9 0 v = '(v(doutN9)-v(doutbN9))/v(vdd)'
