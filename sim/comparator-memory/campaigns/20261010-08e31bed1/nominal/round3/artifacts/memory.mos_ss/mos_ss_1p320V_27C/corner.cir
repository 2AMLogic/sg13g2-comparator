* klt sim -- generated corner deck, do not edit
.lib /opt/pdk/ihp-sg13g2/libs.tech/ngspice/models/cornerMOSlv.lib mos_ss
.include /var/tmp/eda-job-klt-sim-67ae17233968/inputs/netlist.cir
.temp 27
.meas tran vdd_meas find v(vdd) at=5n
.meas tran temp_meas find v(tcheck) at=1n
.meas tran lo_p_meas find v(loP) at=1n
.meas tran lo_n_meas find v(loN) at=1n
.meas tran d_p_1 find v(dP1) at=109n
.meas tran s_p_1 find v(sP1) at=109n
.meas tran d_p_2 find v(dP2) at=109n
.meas tran s_p_2 find v(sP2) at=109n
.meas tran d_p_3 find v(dP3) at=109n
.meas tran s_p_3 find v(sP3) at=109n
.meas tran d_p_4 find v(dP4) at=109n
.meas tran s_p_4 find v(sP4) at=109n
.meas tran d_p_5 find v(dP5) at=109n
.meas tran s_p_5 find v(sP5) at=109n
.meas tran d_p_6 find v(dP6) at=109n
.meas tran s_p_6 find v(sP6) at=109n
.meas tran d_p_7 find v(dP7) at=109n
.meas tran s_p_7 find v(sP7) at=109n
.meas tran d_p_8 find v(dP8) at=109n
.meas tran s_p_8 find v(sP8) at=109n
.meas tran d_p_9 find v(dP9) at=109n
.meas tran s_p_9 find v(sP9) at=109n
.meas tran d_n_1 find v(dN1) at=109n
.meas tran s_n_1 find v(sN1) at=109n
.meas tran d_n_2 find v(dN2) at=109n
.meas tran s_n_2 find v(sN2) at=109n
.meas tran d_n_3 find v(dN3) at=109n
.meas tran s_n_3 find v(sN3) at=109n
.meas tran d_n_4 find v(dN4) at=109n
.meas tran s_n_4 find v(sN4) at=109n
.meas tran d_n_5 find v(dN5) at=109n
.meas tran s_n_5 find v(sN5) at=109n
.meas tran d_n_6 find v(dN6) at=109n
.meas tran s_n_6 find v(sN6) at=109n
.meas tran d_n_7 find v(dN7) at=109n
.meas tran s_n_7 find v(sN7) at=109n
.meas tran d_n_8 find v(dN8) at=109n
.meas tran s_n_8 find v(sN8) at=109n
.meas tran d_n_9 find v(dN9) at=109n
.meas tran s_n_9 find v(sN9) at=109n
.control
alter vsup=1.32
tran 5p 110n
quit
.endc
.end
