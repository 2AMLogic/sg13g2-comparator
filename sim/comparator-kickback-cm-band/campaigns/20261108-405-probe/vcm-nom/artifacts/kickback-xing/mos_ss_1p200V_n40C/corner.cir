* klt sim -- generated corner deck, do not edit
.lib /opt/pdk/ihp-sg13g2/libs.tech/ngspice/models/cornerMOSlv.lib mos_ss
.include /var/tmp/eda-job-klt-sim-a8e021e71c38/inputs/netlist.cir
.temp -40.0
.meas tran vdd_meas find v(vdd) at=25n
.meas tran temp_meas find v(tcheck) at=1n
.meas tran ad_pos max v(ad) from=30n to=45n
.meas tran ad_neg min v(ad) from=30n to=45n
.meas tran kick_1k_peak_mv param='max(abs(ad_pos),abs(ad_neg))*1e3'
.meas tran kick_1k_pos_mv param='ad_pos*1e3'
.meas tran kick_1k_neg_mv param='ad_neg*1e3'
.meas tran qp29 find v(qp) at=29n
.meas tran qpmax max v(qp) from=30n to=45n
.meas tran qpmin min v(qp) from=30n to=45n
.meas tran qn29 find v(qn) at=29n
.meas tran qnmax max v(qn) from=30n to=45n
.meas tran qnmin min v(qn) from=30n to=45n
.meas tran qkick_p_fc param='max(abs(qpmax-qp29),abs(qpmin-qp29))*1e3'
.meas tran qkick_n_fc param='max(abs(qnmax-qn29),abs(qnmin-qn29))*1e3'
.meas tran qkick_fc param='max(qkick_p_fc,qkick_n_fc)'
.meas tran bd0 find v(bd) at=29n
.meas tran bd1 find v(bd) at=55n
.meas tran cd0 find v(cd) at=29n
.meas tran cd1 find v(cd) at=55n
.meas tran kick_sigdep_uv param='abs((cd1-cd0)-(bd1-bd0))*1e6'
.meas tran bc0 find v(bc) at=29n
.meas tran bc1 find v(bc) at=55n
.meas tran kick_cm_uv param='(bc1-bc0)*1e6'
.meas tran dout_1k_end find v(dan) at=55n
.meas tran dout_float_small_end find v(dbn) at=55n
.meas tran dout_float_big_end find v(dcn) at=55n
.meas tran vcm_meas find v(cm) at=5n
.meas tran b_dp_30n find v(doutb) at=30n
.meas tran b_dn_30n find v(doutbb) at=30n
.meas tran b_dp_31n find v(doutb) at=31n
.meas tran b_dn_31n find v(doutbb) at=31n
.meas tran b_dp_32n find v(doutb) at=32n
.meas tran b_dn_32n find v(doutbb) at=32n
.meas tran b_dp_34n find v(doutb) at=34n
.meas tran b_dn_34n find v(doutbb) at=34n
.meas tran b_dp_36n find v(doutb) at=36n
.meas tran b_dn_36n find v(doutbb) at=36n
.meas tran b_dp_40n find v(doutb) at=40n
.meas tran b_dn_40n find v(doutbb) at=40n
.meas tran b_dp_45n find v(doutb) at=45n
.meas tran b_dn_45n find v(doutbb) at=45n
.meas tran b_dp_50n find v(doutb) at=50n
.meas tran b_dn_50n find v(doutbb) at=50n
.meas tran b_dp_55n find v(doutb) at=55n
.meas tran b_dn_55n find v(doutbb) at=55n
.meas tran b_vd_strobe find v(bd) at=30n
.meas tran b_vd_1n find v(bd) at=1n
.meas tran c_dp_30n find v(doutc) at=30n
.meas tran c_dn_30n find v(doutbc) at=30n
.meas tran c_dp_31n find v(doutc) at=31n
.meas tran c_dn_31n find v(doutbc) at=31n
.meas tran c_dp_32n find v(doutc) at=32n
.meas tran c_dn_32n find v(doutbc) at=32n
.meas tran c_dp_34n find v(doutc) at=34n
.meas tran c_dn_34n find v(doutbc) at=34n
.meas tran c_dp_36n find v(doutc) at=36n
.meas tran c_dn_36n find v(doutbc) at=36n
.meas tran c_dp_40n find v(doutc) at=40n
.meas tran c_dn_40n find v(doutbc) at=40n
.meas tran c_dp_45n find v(doutc) at=45n
.meas tran c_dn_45n find v(doutbc) at=45n
.meas tran c_dp_50n find v(doutc) at=50n
.meas tran c_dn_50n find v(doutbc) at=50n
.meas tran c_dp_55n find v(doutc) at=55n
.meas tran c_dn_55n find v(doutbc) at=55n
.meas tran c_vd_strobe find v(cd) at=30n
.meas tran c_vd_1n find v(cd) at=1n
.meas tran b_t_half when v(dbn)=0.5 td=30n cross=1
.meas tran b_t_pair when v(doutb)=v(doutbb) td=30n cross=1
.meas tran c_t_half when v(dcn)=0.5 td=30n cross=1
.meas tran c_t_pair when v(doutc)=v(doutbc) td=30n cross=1
.control
save all
alter vsup=1.2
tran 5p 60n
quit
.endc
.end
