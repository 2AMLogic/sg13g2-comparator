* kickback -- klt sim netlist BODY (sim/comparator-kickback-cm-band, issue #165) condition=vcm-m050 vcm_delta=-0.05
* GENERATED by `python3 sim/run_kickback_cm_band.py build` from the issue #62 kickback body (sim/kltsim/kickback_cmband.py) -- do not edit;
* edit the inputs below and rebuild.
*   circuit: sim/klt-corner-verification/benches/kickback.circuit.spice  sha256=f2c04290b2e35237cd760780031918fe8cb8da27bf1f917fd96184bf1368403e
*   DUT:     design/comparator.spice  sha256=b31b936dd78634b224d882e5f43ceb3b43eb34e5c3400336f09213cef8a39b90
*            sim/dut.json id=comparator-dr0001 provenance=schematic
*   OSDI:    /opt/pdk/ihp-sg13g2/libs.tech/ngspice/osdi
*
* klt sim netlist-body convention: no .lib / .temp / analysis / .end here --
* klt sim generates those per corner around an .include of this file. The
* .control block below is the one deliberate deviation (see
* sim/kltsim/build.py): SG13G2's MOS models are OSDI and must be
* pre_osdi-loaded before the circuit is parsed, and the pinned klt has no
* request field for that.
.control
pre_osdi /opt/pdk/ihp-sg13g2/libs.tech/ngspice/osdi/psp103.osdi
pre_osdi /opt/pdk/ihp-sg13g2/libs.tech/ngspice/osdi/psp103_nqs.osdi
pre_osdi /opt/pdk/ihp-sg13g2/libs.tech/ngspice/osdi/r3_cmc.osdi
pre_osdi /opt/pdk/ihp-sg13g2/libs.tech/ngspice/osdi/mosvar.osdi
.endc

* ---- DUT operating point (sim/dut.json params) ----
.param dut_ib=2e-05
.param dut_vcm=0.6

* ==== BEGIN DUT design/comparator.spice sha256=b31b936dd78634b224d882e5f43ceb3b43eb34e5c3400336f09213cef8a39b90 ====
* ============================================================================
* sg13g2-comparator -- DERIVED NETLIST.  DO NOT EDIT BY HAND.
* ============================================================================
*
* Generated from the xschem sources in design/ by:
*
*     python3 design/netlist.py
*
* The schematics are the source of record:
*
*   design/comparator.sch              the design -- a single-tail StrongARM
*                                      dynamic latch (spec/decision-records/
*                                      0001-comparator-topology.md), plus the
*                                      isolation inverters and NOR SR latch
*                                      that make its outputs HELD between
*                                      strobes as the interface contract
*                                      requires
*   design/comparator_dut.sch          contract wrapper: tail-bias reference
*                                      on the `ibias` pin + the core
*   design/comparator_dut_latch.sch    contract wrapper: the core with its
*                                      tail-bias node tied to vdd
*   design/comparator_dut_analog.sch   the LOOP-BROKEN reduced sub-model --
*                                      an offset/noise LOWER BOUND, not the
*                                      design's front end.  Read
*                                      design/README.md before quoting any
*                                      number measured against it.
*
* Interface contract: sim/dut/README.md.  Asserted at generation time by
* design/netlist.py (against sim/harness/dut.py's own REQUIRED_SUBCKTS) and
* again at load time by the harness.
*
* Parameters supplied by the harness, not by this file: dut_ib, dut_vcm,
* vdd_val, vdd_nom, temp_c (sim/harness/runner.py compose_deck).  This file
* deliberately contains no .include / .lib / .temp / .control / .endc / .end.
* ============================================================================

.subckt comparator vinp vinn clk vbias dout doutb vdd vss
*.iopin vinp
*.iopin vinn
*.iopin clk
*.iopin vbias
*.iopin dout
*.iopin doutb
*.iopin vdd
*.iopin vss
XMT tmid vbias vss vss sg13_lv_nmos w=40u l=0.5u ng=1 m=1
XMSW tail clk tmid vss sg13_lv_nmos w=40u l=0.13u ng=1 m=1
XM1 np vinp tail vss sg13_lv_nmos w=12u l=0.34u ng=1 m=1
XM2 nn vinn tail vss sg13_lv_nmos w=12u l=0.34u ng=1 m=1
XM3 ln lp np vss sg13_lv_nmos w=3u l=0.13u ng=1 m=1
XM4 lp ln nn vss sg13_lv_nmos w=3u l=0.13u ng=1 m=1
XM5 ln lp vdd vdd sg13_lv_pmos w=3u l=0.13u ng=1 m=1
XM6 lp ln vdd vdd sg13_lv_pmos w=3u l=0.13u ng=1 m=1
XM7 ln clk vdd vdd sg13_lv_pmos w=6u l=0.13u ng=1 m=1
XM8 lp clk vdd vdd sg13_lv_pmos w=6u l=0.13u ng=1 m=1
XM9 np clk vdd vdd sg13_lv_pmos w=3u l=0.13u ng=1 m=1
XM10 nn clk vdd vdd sg13_lv_pmos w=3u l=0.13u ng=1 m=1
XMIAP lnb ln vdd vdd sg13_lv_pmos w=3u l=0.13u ng=1 m=1
XMIAN lnb ln vss vss sg13_lv_nmos w=1.5u l=0.13u ng=1 m=1
XMIBP lpb lp vdd vdd sg13_lv_pmos w=3u l=0.13u ng=1 m=1
XMIBN lpb lp vss vss sg13_lv_nmos w=1.5u l=0.13u ng=1 m=1
XMNAP1 na lnb vdd vdd sg13_lv_pmos w=4u l=0.13u ng=1 m=1
XMNAP2 doutb dout na vdd sg13_lv_pmos w=4u l=0.13u ng=1 m=1
XMNAN1 doutb lnb vss vss sg13_lv_nmos w=1.5u l=0.13u ng=1 m=1
XMNAN2 doutb dout vss vss sg13_lv_nmos w=1.5u l=0.13u ng=1 m=1
XMNBP1 nb lpb vdd vdd sg13_lv_pmos w=4u l=0.13u ng=1 m=1
XMNBP2 dout doutb nb vdd sg13_lv_pmos w=4u l=0.13u ng=1 m=1
XMNBN1 dout lpb vss vss sg13_lv_nmos w=1.5u l=0.13u ng=1 m=1
XMNBN2 dout doutb vss vss sg13_lv_nmos w=1.5u l=0.13u ng=1 m=1
.ends

.subckt comparator_dut_analog vinp vinn ibias aop aon vdd vss
*.iopin vinp
*.iopin vinn
*.iopin ibias
*.iopin aop
*.iopin aon
*.iopin vdd
*.iopin vss
XMBA ibias ibias vss vss sg13_lv_nmos w=10u l=0.5u ng=1 m=1
XMTA tmid ibias vss vss sg13_lv_nmos w=40u l=0.5u ng=1 m=1
XMSWA tail vdd tmid vss sg13_lv_nmos w=40u l=0.13u ng=1 m=1
XM1A aon vinp tail vss sg13_lv_nmos w=12u l=0.34u ng=1 m=1
XM2A aop vinn tail vss sg13_lv_nmos w=12u l=0.34u ng=1 m=1
XM5A aon aon vdd vdd sg13_lv_pmos w=3u l=0.13u ng=1 m=1
XM6A aop aop vdd vdd sg13_lv_pmos w=3u l=0.13u ng=1 m=1
.ends

.subckt comparator_dut_latch inp inn clk dout doutb vdd vss
*.iopin inp
*.iopin inn
*.iopin clk
*.iopin dout
*.iopin doutb
*.iopin vdd
*.iopin vss
x1 inp inn clk vdd dout doutb vdd vss comparator
.ends

.subckt comparator_dut vinp vinn clk ibias dout doutb vdd vss
*.iopin vinp
*.iopin vinn
*.iopin clk
*.iopin ibias
*.iopin dout
*.iopin doutb
*.iopin vdd
*.iopin vss
XMB ibias ibias vss vss sg13_lv_nmos w=10u l=0.5u ng=1 m=1
x1 vinp vinn clk ibias dout doutb vdd vss comparator
.ends
* ==== END DUT ====

* ---- bench: kickback (klt sim port of sim/comparator-kickback) ----------
*
* Circuit is sim/comparator-kickback/testbench/tb_kickback.spice's, carried
* over element for element (branch A: 1 kohm / 100 fF; branches B/C: 1 Gohm
* / 1 pF floating inputs at 1 mV and 100 mV), with two changes:
*
* 1. SUPPLY-TRACKING CLOCK. klt sim sweeps supply by `alter vsup=<V>`, which
*    does not reach the original `pulse(0 {vdd_val} ...)` amplitude, so the
*    strobe here is a unit pulse scaled by the live supply node (Bclk) --
*    same timing, rail-to-rail at every supply corner.
*
* 2. A DIRECT Q_kick MEASUREMENT on branch A, which DR-0002 Row 4 names as an
*    open item ("A direct Q_kick measurement in the kickback bench"). The
*    original deck emits no charge at all; DR-0002 Row 4 (b) shows the only
*    available estimator (peak volts x C_in) under-reports by ~1.3-2.9x.
*    Here each branch-A DUT input pin is reached through a 0 V ammeter
*    (vkp / vkn), so i(vkp) is exactly the DUT + input pin's own current.
*    A behavioural current source integrates it onto a 1 pF capacitor
*    (Bqp -> qp), so v(qp) [V] x 1000 is the running pin charge in fC. Sign:
*    oriented so that v(qp) RISES when the DUT pushes charge INTO node apa
*    (checked in the single-corner smoke: v(qp) - v(qp)@29ns peaks positive
*    in the same window where v(ad) = v(apa) - v(asp) peaks positive). The
*    sign does not enter the graded number, which is an absolute value. The
*    request measures v(qp) at 29 ns (DR-0002's pre-decision reference) and
*    its max/min over the 30 ... 45 ns window, so
*        Q_kick = max_t |q(t) - q(29 ns)|,  t in [30 ns, 45 ns]
*    which is DR-0002 Row 4's definition `max_t |int i_kick dt'|` verbatim.
*    The ammeters are ideal 0 V sources and the integrators load nothing,
*    so the circuit the DUT sees is the original one. Rqp only gives the
*    integrator node a DC path: tau = 1 ms (~10^5 x the 15 ns window), and
*    small enough that the pin's DC leakage parks v(qp) at only mV, so the
*    6-significant-figure .meas print keeps sub-0.001 fC resolution.

.options reltol=1e-4 vntol=1e-9 abstol=1e-15 chgtol=1e-16

.param rsrc=1k
.param cin=100f
.param rfloat=1G
.param cfloat=1p
.param dv_small=1m
.param dv_big=100m

vsup vdd 0 dc 1.2
* ---- CM-band condition (issue #165): vcm-m050, input common mode = dut_vcm + vcm_delta
.param vcm_delta=-0.05
vcm cm 0 dc {dut_vcm+vcm_delta}

* One strobe at 30 ns, as in the original (`pulse(0 {vdd_val} 30n 100p
* 100p 10n 30n)`), scaled by the altered supply.
vclku clku 0 pulse(0 1 30n 100p 100p 10n 30n)
Bclk  clk  0 v = 'v(clku)*v(vdd)'

* ---- A: 1 kohm source impedance (DR-0002 Row 4's stated condition) ------
vsa  sa 0 dc {dv_small}
Easp asp cm sa 0 0.5
Easn asn cm sa 0 -0.5
Rap  asp apa {rsrc}
Ran  asn ana {rsrc}
Cap  apa 0 {cin}
Can  ana 0 {cin}
* 0 V ammeters into the DUT pins (new; see header item 2)
vkp  apa apa_pin dc 0
vkn  ana ana_pin dc 0
iba  vdd ibna dc {dut_ib}
Xa   apa_pin ana_pin clk ibna douta doutba vdd 0 comparator_dut

* ---- branch-A injected-charge integrators (new; see header item 2) ------
Bqp  0 qp i = 'i(vkp)'
Cqp  qp 0 1p
Rqp  qp 0 1e9
Bqn  0 qn i = 'i(vkn)'
Cqn  qn 0 1p
Rqn  qn 0 1e9

* ---- B: floating high-Z input, small residue ----------------------------
vsb  sb 0 dc {dv_small}
Ebsp bsp cm sb 0 0.5
Ebsn bsn cm sb 0 -0.5
Rbp  bsp bpp {rfloat}
Rbn  bsn bpn {rfloat}
Cbp  bpp 0 {cfloat}
Cbn  bpn 0 {cfloat}
ibb  vdd ibnb dc {dut_ib}
Xb   bpp bpn clk ibnb doutb doutbb vdd 0 comparator_dut

* ---- C: floating high-Z input, large residue ----------------------------
vsc  sc 0 dc {dv_big}
Ecsp csp cm sc 0 0.5
Ecsn csn cm sc 0 -0.5
Rcp  csp cpp {rfloat}
Rcn  csn cpn {rfloat}
Ccp  cpp 0 {cfloat}
Ccn  cpn 0 {cfloat}
ibc  vdd ibnc dc {dut_ib}
Xc   cpp cpn clk ibnc doutc doutbc vdd 0 comparator_dut

* ---- near-zero-referenced probes (as in the original) -------------------
Bad ad 0 v = 'v(apa)-v(asp)'
Bbd bd 0 v = 'v(bpp)-v(bpn)'
Bcd cd 0 v = 'v(cpp)-v(cpn)'
Bbc bc 0 v = '(v(bpp)+v(bpn))/2-v(cm)'

* ---- supply-normalized decision probes ----------------------------------
Bdan dan 0 v = 'v(douta)/v(vdd)'
Bdbn dbn 0 v = 'v(doutb)/v(vdd)'
Bdcn dcn 0 v = 'v(doutc)/v(vdd)'

* ---- corner-application probe (see regeneration bench) ------------------
Btchk tcheck 0 v = 'temper'

* ---- issue #415 supplement (arm icdc): forced DC operating point ----------
* Appended verbatim after the issue #165 body; nothing else changed.
* .nodeset: at DC no current flows through rfloat, so each floating pin sits
* at its ideal source's value v(cm) +/- dv/2; the hint starts the DC solve
* there instead of letting gmin stepping fail. .ic: every branch output is
* seeded LOW (dout=0) -- the WRONG polarity for the programmed differential
* and the state the rejects already hold on their failing branch; the
* complementary nodes are left to the latch. No arm is forced toward the
* expected answer, so a 55 ns gate pass needs a real post-strobe decision.
* No uic on the tran: ngspice seeds (does not pin) the solve, the bistable
* latch lands in the seeded basin, and the realized start state is re-read
* from the 1 ns observables (series README).
.nodeset v(bpp)=0.5505 v(bpn)=0.5495 v(cpp)=0.6 v(cpn)=0.5
.ic v(douta)=0 v(doutb)=0 v(doutc)=0
