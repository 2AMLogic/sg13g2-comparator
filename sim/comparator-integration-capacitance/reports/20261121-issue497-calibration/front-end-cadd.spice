* Issue 477 characterization only. Core and wrappers from design/comparator.spice
* (b31b936dd78634b224d882e5f43ceb3b43eb34e5c3400336f09213cef8a39b90).
* Apply the full-latch geometry to its counterpart in the loop-broken model.
.param pair_w=12u pair_l=0.34u switch_w=40u latch_w=3u c_add=0
.param dut_ib=20u dut_vcm=0.6 vdd_val=1.2
.subckt comparator vinp vinn clk vbias dout doutb vdd vss
XMT tmid vbias vss vss sg13_lv_nmos w=40u l=0.5u ng=1 m=1
XMSW tail clk tmid vss sg13_lv_nmos w={switch_w} l=0.13u ng=1 m=1
XM1 np vinp tail vss sg13_lv_nmos w={pair_w} l={pair_l} ng=1 m=1
XM2 nn vinn tail vss sg13_lv_nmos w={pair_w} l={pair_l} ng=1 m=1
XM3 ln lp np vss sg13_lv_nmos w={latch_w} l=0.13u ng=1 m=1
XM4 lp ln nn vss sg13_lv_nmos w={latch_w} l=0.13u ng=1 m=1
XM5 ln lp vdd vdd sg13_lv_pmos w={latch_w} l=0.13u ng=1 m=1
XM6 lp ln vdd vdd sg13_lv_pmos w={latch_w} l=0.13u ng=1 m=1
XM7 ln clk vdd vdd sg13_lv_pmos w=6u l=0.13u ng=1 m=1
XM8 lp clk vdd vdd sg13_lv_pmos w=6u l=0.13u ng=1 m=1
XM9 np clk vdd vdd sg13_lv_pmos w=3u l=0.13u ng=1 m=1
XM10 nn clk vdd vdd sg13_lv_pmos w=3u l=0.13u ng=1 m=1
XMIAP lnb ln vdd vdd sg13_lv_pmos w=3u l=0.13u ng=1 m=1
XMIAN lnb ln vss vss sg13_lv_nmos w=1.5u l=0.13u ng=1 m=1
XMIBP lpb lp vdd vdd sg13_lv_pmos w=3u l=0.13u ng=1 m=1
XMIBN lpb lp vss vss sg13_lv_nmos w=1.5u l=0.13u ng=1 m=1
XMNAP1 na lnb vdd vdd sg13_lv_pmos w=4u l=0.13u ng=1 m=1
XMNAP2 doutb dout na vdd sg13_lv_pmos w=4u l=0.13u ng=1 m=1
XMNAN1 doutb lnb vss vss sg13_lv_nmos w=1.5u l=0.13u ng=1 m=1
XMNAN2 doutb dout vss vss sg13_lv_nmos w=1.5u l=0.13u ng=1 m=1
XMNBP1 nb lpb vdd vdd sg13_lv_pmos w=4u l=0.13u ng=1 m=1
XMNBP2 dout doutb nb vdd sg13_lv_pmos w=4u l=0.13u ng=1 m=1
XMNBN1 dout lpb vss vss sg13_lv_nmos w=1.5u l=0.13u ng=1 m=1
XMNBN2 dout doutb vss vss sg13_lv_nmos w=1.5u l=0.13u ng=1 m=1
* issue #497: the candidate's matched integration-node capacitance, mapped
* node-to-node onto this model (np -> aon, nn -> aop)
C497P np vss {c_add}
C497N nn vss {c_add}
.ends

.subckt comparator_dut_analog vinp vinn ibias aop aon vdd vss
XMBA ibias ibias vss vss sg13_lv_nmos w=10u l=0.5u ng=1 m=1
XMTA tmid ibias vss vss sg13_lv_nmos w=40u l=0.5u ng=1 m=1
XMSWA tail vdd tmid vss sg13_lv_nmos w={switch_w} l=0.13u ng=1 m=1
XM1A aon vinp tail vss sg13_lv_nmos w={pair_w} l={pair_l} ng=1 m=1
XM2A aop vinn tail vss sg13_lv_nmos w={pair_w} l={pair_l} ng=1 m=1
XM5A aon aon vdd vdd sg13_lv_pmos w={latch_w} l=0.13u ng=1 m=1
XM6A aop aop vdd vdd sg13_lv_pmos w={latch_w} l=0.13u ng=1 m=1
C497AP aon vss {c_add}
C497AN aop vss {c_add}
.ends

.subckt comparator_dut_latch inp inn clk dout doutb vdd vss
x1 inp inn clk vdd dout doutb vdd vss comparator
.ends

.subckt comparator_dut vinp vinn clk ibias dout doutb vdd vss
XMB ibias ibias vss vss sg13_lv_nmos w=10u l=0.5u ng=1 m=1
x1 vinp vinn clk ibias dout doutb vdd vss comparator
.ends

.include "../../../comparator-preamp-noise/testbench/tb_preamp_noise.spice"
